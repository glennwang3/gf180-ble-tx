** GF180 KLayout LVS reference generated from the xschem netlist
.subckt current_steering_dac voutp voutn d6 d7b d3 d5b d5 d1 d6b d3b d7 d2b d2 d1b d4 d0b d0 d4b vb vss
m1 voutp d0 net1 vss nfet_03v3 L=0.28u W=0.56u
m2 voutn d0b net1 vss nfet_03v3 L=0.28u W=0.56u
m7 net1 vb vss vss nfet_03v3 L=1u W=2u
m3 voutp d1 net2 vss nfet_03v3 L=0.28u W=1.12u
m4 voutn d1b net2 vss nfet_03v3 L=0.28u W=1.12u
m5 net2 vb vss vss nfet_03v3 L=1u W=4u
m6 voutp d2 net3 vss nfet_03v3 L=0.28u W=2.24u
m8 voutn d2b net3 vss nfet_03v3 L=0.28u W=2.24u
m9 net3 vb vss vss nfet_03v3 L=1u W=8u
m10 voutp d3 net4 vss nfet_03v3 L=0.28u W=4.48u
m11 voutn d3b net4 vss nfet_03v3 L=0.28u W=4.48u
m12 net4 vb vss vss nfet_03v3 L=1u W=16u
m13 voutp d4 net5 vss nfet_03v3 L=0.28u W=8.96u
m14 voutn d4b net5 vss nfet_03v3 L=0.28u W=8.96u
m15 net5 vb vss vss nfet_03v3 L=1u W=32u
m16 voutp d5 net6 vss nfet_03v3 L=0.28u W=17.92u
m17 voutn d5b net6 vss nfet_03v3 L=0.28u W=17.92u
m18 net6 vb vss vss nfet_03v3 L=1u W=64u
m19 voutp d6 net7 vss nfet_03v3 L=0.28u W=35.84u
m20 voutn d6b net7 vss nfet_03v3 L=0.28u W=35.84u
m21_p1 net7 vb vss vss nfet_03v3 L=1u W=64u
m21_p2 net7 vb vss vss nfet_03v3 L=1u W=64u
m23_p1 voutp d7 net8 vss nfet_03v3 L=0.28u W=35.84u
m23_p2 voutp d7 net8 vss nfet_03v3 L=0.28u W=35.84u
m22_p1 voutn d7b net8 vss nfet_03v3 L=0.28u W=35.84u
m22_p2 voutn d7b net8 vss nfet_03v3 L=0.28u W=35.84u
m25_p1 net8 vb vss vss nfet_03v3 L=1u W=64u
m25_p2 net8 vb vss vss nfet_03v3 L=1u W=64u
m25_p3 net8 vb vss vss nfet_03v3 L=1u W=64u
m25_p4 net8 vb vss vss nfet_03v3 L=1u W=64u
.ends current_steering_dac
