* NGSPICE file created from current_steering_dac.ext - technology: gf180mcuD

.subckt current_steering_dac d0 d0b d1 d1b d2 d2b d3 d3b d4 d4b d5 d5b d6 d6b d7 d7b
+ voutp voutn vb vss
X0 vss.t42 vb.t0 a_52100_11736# vss.t26 nfet_03v3 ad=24p pd=35u as=24p ps=35u w=16u l=1u
X1 a_30700_9584# d5b.t0 voutn.t9 vss.t0 nfet_03v3 ad=13.44p pd=20.92u as=13.44p ps=20.92u w=8.96u l=0.28u
X2 a_52100_11736# d7.t4 voutp.t8 vss.t48 nfet_03v3 ad=21.51p pd=31.68u as=21.51p ps=31.68u w=14.34u l=0.28u
X3 vss.t15 vb.t27 a_30700_9584# vss.t12 nfet_03v3 ad=24p pd=35u as=24p ps=35u w=16u l=1u
X4 vss.t18 vb.t24 a_30700_9584# vss.t12 nfet_03v3 ad=24p pd=35u as=24p ps=35u w=16u l=1u
X5 vss.t30 vb.t12 a_52100_11736# vss.t26 nfet_03v3 ad=24p pd=35u as=24p ps=35u w=16u l=1u
X6 vss.t13 vb.t29 a_24400_9584# vss.t12 nfet_03v3 ad=24p pd=35u as=24p ps=35u w=16u l=1u
X7 vss.t41 vb.t1 a_52100_11736# vss.t26 nfet_03v3 ad=24p pd=35u as=24p ps=35u w=16u l=1u
X8 a_52100_11736# d7b.t1 voutn.t12 vss.t46 nfet_03v3 ad=21.5025p pd=31.67u as=21.5025p ps=31.67u w=14.335u l=0.28u
X9 a_30700_9584# d5.t1 voutp.t9 vss.t56 nfet_03v3 ad=13.44p pd=20.92u as=13.44p ps=20.92u w=8.96u l=0.28u
X10 a_52100_11736# d7.t3 voutp.t6 vss.t49 nfet_03v3 ad=21.5025p pd=31.67u as=21.5025p ps=31.67u w=14.335u l=0.28u
X11 vss.t22 vb.t19 a_39200_10780# vss.t10 nfet_03v3 ad=24p pd=35u as=24p ps=35u w=16u l=1u
X12 vss.t29 vb.t13 a_52100_11736# vss.t26 nfet_03v3 ad=24p pd=35u as=24p ps=35u w=16u l=1u
X13 a_14000_6896# d2.t0 voutp.t4 vss.t53 nfet_03v3 ad=3.36p pd=7.48u as=3.36p ps=7.48u w=2.24u l=0.28u
X14 a_24400_9584# d4.t0 voutp.t11 vss.t56 nfet_03v3 ad=13.44p pd=20.92u as=13.44p ps=20.92u w=8.96u l=0.28u
X15 vss.t19 vb.t23 a_39200_10780# vss.t10 nfet_03v3 ad=24p pd=35u as=24p ps=35u w=16u l=1u
X16 a_30700_9584# d5b.t1 voutn.t8 vss.t0 nfet_03v3 ad=13.44p pd=20.92u as=13.44p ps=20.92u w=8.96u l=0.28u
X17 a_39200_10780# d6.t2 voutp.t12 vss.t57 nfet_03v3 ad=17.925p pd=26.9u as=17.925p ps=26.9u w=11.95u l=0.28u
X18 a_39200_10780# d6.t1 voutp.t13 vss.t58 nfet_03v3 ad=17.9175p pd=26.89u as=17.9175p ps=26.89u w=11.945u l=0.28u
X19 vss.t7 vb.t32 a_8800_6448# vss.t6 nfet_03v3 ad=6p pd=11u as=6p ps=11u w=4u l=1u
X20 vss.t40 vb.t2 a_52100_11736# vss.t26 nfet_03v3 ad=24p pd=35u as=24p ps=35u w=16u l=1u
X21 a_52100_11736# d7b.t0 voutn.t13 vss.t46 nfet_03v3 ad=21.5025p pd=31.67u as=21.5025p ps=31.67u w=14.335u l=0.28u
X22 a_19200_7792# d3.t0 voutp.t5 vss.t54 nfet_03v3 ad=6.72p pd=11.96u as=6.72p ps=11.96u w=4.48u l=0.28u
X23 vss.t28 vb.t14 a_52100_11736# vss.t26 nfet_03v3 ad=24p pd=35u as=24p ps=35u w=16u l=1u
X24 a_24400_9584# d4b.t0 voutn.t0 vss.t0 nfet_03v3 ad=13.44p pd=20.92u as=13.44p ps=20.92u w=8.96u l=0.28u
X25 a_52100_11736# d7.t2 voutp.t1 vss.t49 nfet_03v3 ad=21.5025p pd=31.67u as=21.5025p ps=31.67u w=14.335u l=0.28u
X26 vss.t21 vb.t20 a_39200_10780# vss.t10 nfet_03v3 ad=24p pd=35u as=24p ps=35u w=16u l=1u
X27 a_3600_6224# d0b.t0 voutn.t5 vss.t47 nfet_03v3 ad=0.84p pd=4.12u as=0.84p ps=4.12u w=0.56u l=0.28u
X28 a_8800_6448# d1.t0 voutp.t2 vss.t51 nfet_03v3 ad=1.68p pd=5.24u as=1.68p ps=5.24u w=1.12u l=0.28u
X29 a_39200_10780# d6.t0 voutp.t14 vss.t58 nfet_03v3 ad=17.9175p pd=26.89u as=17.9175p ps=26.89u w=11.945u l=0.28u
X30 vss.t39 vb.t3 a_52100_11736# vss.t26 nfet_03v3 ad=24p pd=35u as=24p ps=35u w=16u l=1u
X31 vss.t17 vb.t25 a_30700_9584# vss.t12 nfet_03v3 ad=24p pd=35u as=24p ps=35u w=16u l=1u
X32 vss.t11 vb.t21 a_39200_10780# vss.t10 nfet_03v3 ad=24p pd=35u as=24p ps=35u w=16u l=1u
X33 vss.t27 vb.t15 a_52100_11736# vss.t26 nfet_03v3 ad=24p pd=35u as=24p ps=35u w=16u l=1u
X34 a_19200_7792# d3b.t0 voutn.t14 vss.t55 nfet_03v3 ad=6.72p pd=11.96u as=6.72p ps=11.96u w=4.48u l=0.28u
X35 a_52100_11736# d7.t1 voutp.t0 vss.t49 nfet_03v3 ad=21.5025p pd=31.67u as=21.5025p ps=31.67u w=14.335u l=0.28u
X36 vss.t38 vb.t4 a_52100_11736# vss.t26 nfet_03v3 ad=24p pd=35u as=24p ps=35u w=16u l=1u
X37 vss.t20 vb.t22 a_39200_10780# vss.t10 nfet_03v3 ad=24p pd=35u as=24p ps=35u w=16u l=1u
X38 a_52100_11736# d7.t0 voutp.t7 vss.t49 nfet_03v3 ad=21.5025p pd=31.67u as=21.5025p ps=31.67u w=14.335u l=0.28u
X39 vss.t37 vb.t5 a_52100_11736# vss.t26 nfet_03v3 ad=24p pd=35u as=24p ps=35u w=16u l=1u
X40 vss.t33 vb.t9 a_52100_11736# vss.t26 nfet_03v3 ad=24p pd=35u as=24p ps=35u w=16u l=1u
X41 vss.t5 vb.t30 a_19200_7792# vss.t4 nfet_03v3 ad=24p pd=35u as=24p ps=35u w=16u l=1u
X42 vss.t9 vb.t31 a_14000_6896# vss.t8 nfet_03v3 ad=12p pd=19u as=12p ps=19u w=8u l=1u
X43 vss.t36 vb.t6 a_52100_11736# vss.t26 nfet_03v3 ad=24p pd=35u as=24p ps=35u w=16u l=1u
X44 vss.t3 vb.t33 a_3600_6224# vss.t2 nfet_03v3 ad=3p pd=7u as=3p ps=7u w=2u l=1u
X45 vss.t16 vb.t26 a_30700_9584# vss.t12 nfet_03v3 ad=24p pd=35u as=24p ps=35u w=16u l=1u
X46 vss.t25 vb.t16 a_39200_10780# vss.t10 nfet_03v3 ad=24p pd=35u as=24p ps=35u w=16u l=1u
X47 a_52100_11736# d7b.t4 voutn.t11 vss.t45 nfet_03v3 ad=21.51p pd=31.68u as=21.51p ps=31.68u w=14.34u l=0.28u
X48 vss.t14 vb.t28 a_24400_9584# vss.t12 nfet_03v3 ad=24p pd=35u as=24p ps=35u w=16u l=1u
X49 vss.t35 vb.t7 a_52100_11736# vss.t26 nfet_03v3 ad=24p pd=35u as=24p ps=35u w=16u l=1u
X50 a_39200_10780# d6b.t2 voutn.t2 vss.t43 nfet_03v3 ad=17.925p pd=26.9u as=17.925p ps=26.9u w=11.95u l=0.28u
X51 a_39200_10780# d6b.t1 voutn.t3 vss.t44 nfet_03v3 ad=17.9175p pd=26.89u as=17.9175p ps=26.89u w=11.945u l=0.28u
X52 a_14000_6896# d2b.t0 voutn.t1 vss.t1 nfet_03v3 ad=3.36p pd=7.48u as=3.36p ps=7.48u w=2.24u l=0.28u
X53 a_8800_6448# d1b.t0 voutn.t7 vss.t50 nfet_03v3 ad=1.68p pd=5.24u as=1.68p ps=5.24u w=1.12u l=0.28u
X54 vss.t24 vb.t17 a_39200_10780# vss.t10 nfet_03v3 ad=24p pd=35u as=24p ps=35u w=16u l=1u
X55 vss.t32 vb.t10 a_52100_11736# vss.t26 nfet_03v3 ad=24p pd=35u as=24p ps=35u w=16u l=1u
X56 a_52100_11736# d7b.t3 voutn.t6 vss.t46 nfet_03v3 ad=21.5025p pd=31.67u as=21.5025p ps=31.67u w=14.335u l=0.28u
X57 vss.t31 vb.t11 a_52100_11736# vss.t26 nfet_03v3 ad=24p pd=35u as=24p ps=35u w=16u l=1u
X58 vss.t34 vb.t8 a_52100_11736# vss.t26 nfet_03v3 ad=24p pd=35u as=24p ps=35u w=16u l=1u
X59 a_39200_10780# d6b.t0 voutn.t4 vss.t44 nfet_03v3 ad=17.9175p pd=26.89u as=17.9175p ps=26.89u w=11.945u l=0.28u
X60 a_3600_6224# d0.t0 voutp.t3 vss.t52 nfet_03v3 ad=0.84p pd=4.12u as=0.84p ps=4.12u w=0.56u l=0.28u
X61 a_30700_9584# d5.t0 voutp.t10 vss.t56 nfet_03v3 ad=13.44p pd=20.92u as=13.44p ps=20.92u w=8.96u l=0.28u
X62 vss.t23 vb.t18 a_39200_10780# vss.t10 nfet_03v3 ad=24p pd=35u as=24p ps=35u w=16u l=1u
X63 a_52100_11736# d7b.t2 voutn.t10 vss.t46 nfet_03v3 ad=21.5025p pd=31.67u as=21.5025p ps=31.67u w=14.335u l=0.28u
R0 d1 d1.t0 119.233
R1 d0 d0.t0 111.933
R2 d2 d2.t0 133.833
R3 d3 d3.t0 163.032
R4 d5.n0 d5.t0 216.103
R5 d5.n0 d5.t1 215.596
R6 d5 d5.n0 5.83621
R7 d4 d4.t0 221.433
R8 d6.n0 d6.t0 254.95
R9 d6.n1 d6.t2 254.573
R10 d6.n0 d6.t1 254.444
R11 d6 d6.n1 5.83621
R12 d6.n1 d6.n0 0.506618
R13 voutp.n13 voutp.t3 38.841
R14 voutp.n12 voutp.t2 30.9457
R15 voutp.n11 voutp.t4 27.0521
R16 voutp.n10 voutp.t5 25.1258
R17 voutp.n9 voutp.t11 24.4662
R18 voutp.n6 voutp.n3 20.6684
R19 voutp.n8 voutp.n7 18.2496
R20 voutp.n6 voutp.n5 18.2496
R21 voutp.n7 voutp.t10 6.72313
R22 voutp.n0 voutp.t7 6.71213
R23 voutp.n4 voutp.t14 6.67785
R24 voutp.n7 voutp.t9 6.21701
R25 voutp.n2 voutp.t6 6.20602
R26 voutp.n1 voutp.t1 6.20602
R27 voutp.n0 voutp.t0 6.20602
R28 voutp.n3 voutp.t8 6.20589
R29 voutp.n5 voutp.t12 6.17219
R30 voutp.n4 voutp.t13 6.17173
R31 voutp.n8 voutp.n6 1.59425
R32 voutp.n9 voutp.n8 1.18175
R33 voutp.n10 voutp.n9 0.9755
R34 voutp.n11 voutp.n10 0.9755
R35 voutp.n12 voutp.n11 0.9755
R36 voutp.n13 voutp.n12 0.9755
R37 voutp.n5 voutp.n4 0.506618
R38 voutp.n1 voutp.n0 0.506618
R39 voutp.n2 voutp.n1 0.506618
R40 voutp.n3 voutp.n2 0.506618
R41 voutp voutp.n13 0.038
R42 d7.n0 d7.t0 286.104
R43 d7.n3 d7.t4 285.729
R44 d7.n2 d7.t3 285.599
R45 d7.n1 d7.t2 285.599
R46 d7.n0 d7.t1 285.599
R47 d7 d7.n3 5.83621
R48 d7.n1 d7.n0 0.506618
R49 d7.n2 d7.n1 0.506618
R50 d7.n3 d7.n2 0.506618
R51 d0b d0b.t0 112.761
R52 d1b d1b.t0 120.112
R53 d2b d2b.t0 134.812
R54 d3b d3b.t0 164.214
R55 d5b.n0 d5b.t0 216.103
R56 d5b.n0 d5b.t1 215.596
R57 d5b d5b.n0 7.42084
R58 d4b d4b.t0 223.018
R59 d6b.n0 d6b.t0 254.95
R60 d6b.n1 d6b.t2 254.573
R61 d6b.n0 d6b.t1 254.444
R62 d6b d6b.n1 7.68994
R63 d6b.n1 d6b.n0 0.506618
R64 voutn.n13 voutn.t5 38.0388
R65 voutn.n12 voutn.t7 30.0932
R66 voutn.n11 voutn.t1 26.0988
R67 voutn.n10 voutn.t14 23.9708
R68 voutn.n9 voutn.t0 22.908
R69 voutn.n6 voutn.n3 18.626
R70 voutn.n8 voutn.n7 16.6915
R71 voutn.n6 voutn.n5 16.4224
R72 voutn.n7 voutn.t9 6.72313
R73 voutn.n0 voutn.t13 6.71213
R74 voutn.n4 voutn.t4 6.67785
R75 voutn.n7 voutn.t8 6.21701
R76 voutn.n2 voutn.t6 6.20602
R77 voutn.n1 voutn.t10 6.20602
R78 voutn.n0 voutn.t12 6.20602
R79 voutn.n3 voutn.t11 6.20589
R80 voutn.n5 voutn.t2 6.17219
R81 voutn.n4 voutn.t3 6.17173
R82 voutn.n8 voutn.n6 1.59425
R83 voutn.n9 voutn.n8 1.18175
R84 voutn.n10 voutn.n9 0.9755
R85 voutn.n11 voutn.n10 0.9755
R86 voutn.n12 voutn.n11 0.9755
R87 voutn.n13 voutn.n12 0.9755
R88 voutn.n5 voutn.n4 0.506618
R89 voutn.n1 voutn.n0 0.506618
R90 voutn.n2 voutn.n1 0.506618
R91 voutn.n3 voutn.n2 0.506618
R92 voutn voutn.n13 0.113
R93 d7b.n0 d7b.t0 286.104
R94 d7b.n3 d7b.t4 285.729
R95 d7b.n2 d7b.t3 285.599
R96 d7b.n1 d7b.t2 285.599
R97 d7b.n0 d7b.t1 285.599
R98 d7b d7b.n3 7.90504
R99 d7b.n1 d7b.n0 0.506618
R100 d7b.n2 d7b.n1 0.506618
R101 d7b.n3 d7b.n2 0.506618
R102 vb.n29 vb.t30 112.713
R103 vb.n27 vb.t28 97.0328
R104 vb.n23 vb.t24 97.0328
R105 vb.n15 vb.t16 97.0328
R106 vb.n0 vb.t0 97.0328
R107 vb.n27 vb.t29 96.4505
R108 vb.n25 vb.t27 96.4505
R109 vb.n24 vb.t26 96.4505
R110 vb.n23 vb.t25 96.4505
R111 vb.n21 vb.t23 96.4505
R112 vb.n20 vb.t22 96.4505
R113 vb.n19 vb.t21 96.4505
R114 vb.n18 vb.t20 96.4505
R115 vb.n17 vb.t19 96.4505
R116 vb.n16 vb.t18 96.4505
R117 vb.n15 vb.t17 96.4505
R118 vb.n14 vb.t15 96.4505
R119 vb.n13 vb.t14 96.4505
R120 vb.n12 vb.t13 96.4505
R121 vb.n11 vb.t12 96.4505
R122 vb.n10 vb.t11 96.4505
R123 vb.n9 vb.t10 96.4505
R124 vb.n8 vb.t9 96.4505
R125 vb.n7 vb.t8 96.4505
R126 vb.n6 vb.t7 96.4505
R127 vb.n5 vb.t6 96.4505
R128 vb.n4 vb.t5 96.4505
R129 vb.n3 vb.t4 96.4505
R130 vb.n2 vb.t3 96.4505
R131 vb.n1 vb.t2 96.4505
R132 vb.n0 vb.t1 96.4505
R133 vb.n30 vb.t31 83.9159
R134 vb.n31 vb.t32 69.5175
R135 vb.n32 vb.t33 62.3183
R136 vb.n22 vb.n14 16.9066
R137 vb.n28 vb.n27 15.4563
R138 vb.n26 vb.n25 15.4563
R139 vb.n22 vb.n21 14.9181
R140 vb.n26 vb.n22 1.59425
R141 vb.n28 vb.n26 1.18175
R142 vb.n29 vb.n28 0.9755
R143 vb.n30 vb.n29 0.9755
R144 vb.n31 vb.n30 0.9755
R145 vb.n32 vb.n31 0.9755
R146 vb.n24 vb.n23 0.582853
R147 vb.n25 vb.n24 0.582853
R148 vb.n16 vb.n15 0.582853
R149 vb.n17 vb.n16 0.582853
R150 vb.n18 vb.n17 0.582853
R151 vb.n19 vb.n18 0.582853
R152 vb.n20 vb.n19 0.582853
R153 vb.n21 vb.n20 0.582853
R154 vb.n1 vb.n0 0.582853
R155 vb.n2 vb.n1 0.582853
R156 vb.n3 vb.n2 0.582853
R157 vb.n4 vb.n3 0.582853
R158 vb.n5 vb.n4 0.582853
R159 vb.n6 vb.n5 0.582853
R160 vb.n7 vb.n6 0.582853
R161 vb.n8 vb.n7 0.582853
R162 vb.n9 vb.n8 0.582853
R163 vb.n10 vb.n9 0.582853
R164 vb.n11 vb.n10 0.582853
R165 vb.n12 vb.n11 0.582853
R166 vb.n13 vb.n12 0.582853
R167 vb.n14 vb.n13 0.582853
R168 vb vb.n32 0.188
R169 vss.n145 vss.n144 58.457
R170 vss.n2322 vss.n144 53.5404
R171 vss.n2863 vss.n2862 49.7801
R172 vss.t26 vss.t10 42.7966
R173 vss.n2320 vss.t4 42.2595
R174 vss.n2976 vss.n78 40.1107
R175 vss.t12 vss.n2320 37.9619
R176 vss.n2870 vss.t47 30.0831
R177 vss.n2321 vss.t12 27.2181
R178 vss.t10 vss.n2321 26.3228
R179 vss.t44 vss.t6 23.995
R180 vss.t56 vss.t54 20.0556
R181 vss.t6 vss.t0 16.1162
R182 vss.n142 vss.t8 15.7581
R183 vss.n2288 vss.t1 14.236
R184 vss.n2283 vss.n144 12.883
R185 vss.n2504 vss.t1 12.5349
R186 vss.n2286 vss.n68 12.3146
R187 vss.n2862 vss.n121 12.3146
R188 vss.n2504 vss.n2503 12.3146
R189 vss.n2976 vss.n2975 12.3146
R190 vss.n2871 vss.n2870 12.3146
R191 vss.n80 vss.n78 12.3146
R192 vss.n2869 vss.n2868 12.3146
R193 vss.n2287 vss.n69 12.3146
R194 vss.n3007 vss.n3006 12.3146
R195 vss.n3009 vss.n3008 12.3146
R196 vss.n2977 vss.t8 12.1768
R197 vss.n2321 vss.n79 11.782
R198 vss.n2864 vss.n2863 11.782
R199 vss.n2978 vss.n2977 11.782
R200 vss.n142 vss.n141 11.782
R201 vss.n2870 vss.t48 11.7292
R202 vss.n2320 vss.n2319 11.7
R203 vss.n2285 vss.n146 11.7
R204 vss.n2322 vss.n143 11.5991
R205 vss.n2284 vss.n120 11.2677
R206 vss.n2289 vss.n2288 11.2677
R207 vss.n2862 vss.n2861 11.2365
R208 vss.n2505 vss.n2504 11.2365
R209 vss.n2323 vss.n2322 11.2135
R210 vss.n2322 vss.t26 11.1024
R211 vss.n2285 vss.n78 10.2071
R212 vss.n2287 vss.n2286 10.028
R213 vss.t54 vss.t53 10.028
R214 vss.t49 vss.n2869 8.28218
R215 vss.n3008 vss.t58 7.61069
R216 vss.t50 vss.t47 7.52116
R217 vss.t55 vss.n2285 5.55146
R218 vss.n3008 vss.n3007 5.01427
R219 vss.t53 vss.t51 5.01427
R220 vss.n2865 vss.n2864 4.5725
R221 vss.n73 vss.n70 4.5613
R222 vss.n75 vss.n74 4.5605
R223 vss.n141 vss.n140 4.5545
R224 vss.n2979 vss.n2978 4.5455
R225 vss.n2908 vss.n79 4.53567
R226 vss.n1493 vss.n1467 4.531
R227 vss.n1553 vss.n1552 4.531
R228 vss.n1405 vss.n1379 4.531
R229 vss.n1465 vss.n1464 4.531
R230 vss.n1317 vss.n1291 4.531
R231 vss.n1377 vss.n1376 4.531
R232 vss.n1229 vss.n1203 4.531
R233 vss.n1289 vss.n1288 4.531
R234 vss.n1141 vss.n1115 4.531
R235 vss.n1201 vss.n1200 4.531
R236 vss.n1053 vss.n1027 4.531
R237 vss.n1113 vss.n1112 4.531
R238 vss.n965 vss.n939 4.531
R239 vss.n1025 vss.n1024 4.531
R240 vss.n877 vss.n851 4.531
R241 vss.n937 vss.n936 4.531
R242 vss.n789 vss.n763 4.531
R243 vss.n849 vss.n848 4.531
R244 vss.n701 vss.n675 4.531
R245 vss.n761 vss.n760 4.531
R246 vss.n613 vss.n587 4.531
R247 vss.n673 vss.n672 4.531
R248 vss.n525 vss.n499 4.531
R249 vss.n585 vss.n584 4.531
R250 vss.n437 vss.n411 4.531
R251 vss.n497 vss.n496 4.531
R252 vss.n349 vss.n323 4.531
R253 vss.n409 vss.n408 4.531
R254 vss.n261 vss.n235 4.531
R255 vss.n321 vss.n320 4.531
R256 vss.n173 vss.n147 4.531
R257 vss.n233 vss.n232 4.531
R258 vss.n2220 vss.n2194 4.531
R259 vss.n2280 vss.n2279 4.531
R260 vss.n2132 vss.n2106 4.531
R261 vss.n2192 vss.n2191 4.531
R262 vss.n2044 vss.n2018 4.531
R263 vss.n2104 vss.n2103 4.531
R264 vss.n1956 vss.n1930 4.531
R265 vss.n2016 vss.n2015 4.531
R266 vss.n1868 vss.n1842 4.531
R267 vss.n1928 vss.n1927 4.531
R268 vss.n1780 vss.n1754 4.531
R269 vss.n1840 vss.n1839 4.531
R270 vss.n1692 vss.n1666 4.531
R271 vss.n1752 vss.n1751 4.531
R272 vss.n1604 vss.n1578 4.531
R273 vss.n1664 vss.n1663 4.531
R274 vss.n2438 vss.n2412 4.531
R275 vss.n2498 vss.n2497 4.531
R276 vss.n2350 vss.n2324 4.531
R277 vss.n2410 vss.n2409 4.531
R278 vss.n2796 vss.n2770 4.531
R279 vss.n2856 vss.n2855 4.531
R280 vss.n2708 vss.n2682 4.531
R281 vss.n2768 vss.n2767 4.531
R282 vss.n2620 vss.n2594 4.531
R283 vss.n2680 vss.n2679 4.531
R284 vss.n2532 vss.n2506 4.531
R285 vss.n2592 vss.n2591 4.531
R286 vss.n2910 vss.n2909 4.531
R287 vss.n2971 vss.n2970 4.531
R288 vss.n95 vss.n81 4.531
R289 vss.n118 vss.n117 4.531
R290 vss.n130 vss.n122 4.531
R291 vss.n138 vss.n137 4.531
R292 vss.n1555 vss.n145 4.52975
R293 vss.n2283 vss.n2282 4.52975
R294 vss.n2500 vss.n2323 4.52975
R295 vss.n2858 vss.n143 4.52975
R296 vss.n1496 vss.n1492 4.5005
R297 vss.n1500 vss.n1499 4.5005
R298 vss.n1501 vss.n1491 4.5005
R299 vss.n1505 vss.n1502 4.5005
R300 vss.n1506 vss.n1490 4.5005
R301 vss.n1510 vss.n1509 4.5005
R302 vss.n1511 vss.n1489 4.5005
R303 vss.n1515 vss.n1512 4.5005
R304 vss.n1516 vss.n1488 4.5005
R305 vss.n1520 vss.n1519 4.5005
R306 vss.n1521 vss.n1487 4.5005
R307 vss.n1526 vss.n1523 4.5005
R308 vss.n1527 vss.n1486 4.5005
R309 vss.n1531 vss.n1530 4.5005
R310 vss.n1532 vss.n1485 4.5005
R311 vss.n1536 vss.n1533 4.5005
R312 vss.n1537 vss.n1484 4.5005
R313 vss.n1541 vss.n1540 4.5005
R314 vss.n1542 vss.n1483 4.5005
R315 vss.n1546 vss.n1543 4.5005
R316 vss.n1547 vss.n1482 4.5005
R317 vss.n1551 vss.n1550 4.5005
R318 vss.n1481 vss.n1480 4.5005
R319 vss.n1550 vss.n1549 4.5005
R320 vss.n1548 vss.n1547 4.5005
R321 vss.n1546 vss.n1545 4.5005
R322 vss.n1544 vss.n1483 4.5005
R323 vss.n1540 vss.n1539 4.5005
R324 vss.n1538 vss.n1537 4.5005
R325 vss.n1536 vss.n1535 4.5005
R326 vss.n1534 vss.n1485 4.5005
R327 vss.n1530 vss.n1529 4.5005
R328 vss.n1528 vss.n1527 4.5005
R329 vss.n1526 vss.n1525 4.5005
R330 vss.n1524 vss.n1487 4.5005
R331 vss.n1519 vss.n1518 4.5005
R332 vss.n1517 vss.n1516 4.5005
R333 vss.n1515 vss.n1514 4.5005
R334 vss.n1513 vss.n1489 4.5005
R335 vss.n1509 vss.n1508 4.5005
R336 vss.n1507 vss.n1506 4.5005
R337 vss.n1505 vss.n1504 4.5005
R338 vss.n1503 vss.n1491 4.5005
R339 vss.n1499 vss.n1498 4.5005
R340 vss.n1497 vss.n1496 4.5005
R341 vss.n1495 vss.n1494 4.5005
R342 vss.n1408 vss.n1404 4.5005
R343 vss.n1412 vss.n1411 4.5005
R344 vss.n1413 vss.n1403 4.5005
R345 vss.n1417 vss.n1414 4.5005
R346 vss.n1418 vss.n1402 4.5005
R347 vss.n1422 vss.n1421 4.5005
R348 vss.n1423 vss.n1401 4.5005
R349 vss.n1427 vss.n1424 4.5005
R350 vss.n1428 vss.n1400 4.5005
R351 vss.n1432 vss.n1431 4.5005
R352 vss.n1433 vss.n1399 4.5005
R353 vss.n1438 vss.n1435 4.5005
R354 vss.n1439 vss.n1398 4.5005
R355 vss.n1443 vss.n1442 4.5005
R356 vss.n1444 vss.n1397 4.5005
R357 vss.n1448 vss.n1445 4.5005
R358 vss.n1449 vss.n1396 4.5005
R359 vss.n1453 vss.n1452 4.5005
R360 vss.n1454 vss.n1395 4.5005
R361 vss.n1458 vss.n1455 4.5005
R362 vss.n1459 vss.n1394 4.5005
R363 vss.n1463 vss.n1462 4.5005
R364 vss.n1393 vss.n1392 4.5005
R365 vss.n1462 vss.n1461 4.5005
R366 vss.n1460 vss.n1459 4.5005
R367 vss.n1458 vss.n1457 4.5005
R368 vss.n1456 vss.n1395 4.5005
R369 vss.n1452 vss.n1451 4.5005
R370 vss.n1450 vss.n1449 4.5005
R371 vss.n1448 vss.n1447 4.5005
R372 vss.n1446 vss.n1397 4.5005
R373 vss.n1442 vss.n1441 4.5005
R374 vss.n1440 vss.n1439 4.5005
R375 vss.n1438 vss.n1437 4.5005
R376 vss.n1436 vss.n1399 4.5005
R377 vss.n1431 vss.n1430 4.5005
R378 vss.n1429 vss.n1428 4.5005
R379 vss.n1427 vss.n1426 4.5005
R380 vss.n1425 vss.n1401 4.5005
R381 vss.n1421 vss.n1420 4.5005
R382 vss.n1419 vss.n1418 4.5005
R383 vss.n1417 vss.n1416 4.5005
R384 vss.n1415 vss.n1403 4.5005
R385 vss.n1411 vss.n1410 4.5005
R386 vss.n1409 vss.n1408 4.5005
R387 vss.n1407 vss.n1406 4.5005
R388 vss.n1320 vss.n1316 4.5005
R389 vss.n1324 vss.n1323 4.5005
R390 vss.n1325 vss.n1315 4.5005
R391 vss.n1329 vss.n1326 4.5005
R392 vss.n1330 vss.n1314 4.5005
R393 vss.n1334 vss.n1333 4.5005
R394 vss.n1335 vss.n1313 4.5005
R395 vss.n1339 vss.n1336 4.5005
R396 vss.n1340 vss.n1312 4.5005
R397 vss.n1344 vss.n1343 4.5005
R398 vss.n1345 vss.n1311 4.5005
R399 vss.n1350 vss.n1347 4.5005
R400 vss.n1351 vss.n1310 4.5005
R401 vss.n1355 vss.n1354 4.5005
R402 vss.n1356 vss.n1309 4.5005
R403 vss.n1360 vss.n1357 4.5005
R404 vss.n1361 vss.n1308 4.5005
R405 vss.n1365 vss.n1364 4.5005
R406 vss.n1366 vss.n1307 4.5005
R407 vss.n1370 vss.n1367 4.5005
R408 vss.n1371 vss.n1306 4.5005
R409 vss.n1375 vss.n1374 4.5005
R410 vss.n1305 vss.n1304 4.5005
R411 vss.n1374 vss.n1373 4.5005
R412 vss.n1372 vss.n1371 4.5005
R413 vss.n1370 vss.n1369 4.5005
R414 vss.n1368 vss.n1307 4.5005
R415 vss.n1364 vss.n1363 4.5005
R416 vss.n1362 vss.n1361 4.5005
R417 vss.n1360 vss.n1359 4.5005
R418 vss.n1358 vss.n1309 4.5005
R419 vss.n1354 vss.n1353 4.5005
R420 vss.n1352 vss.n1351 4.5005
R421 vss.n1350 vss.n1349 4.5005
R422 vss.n1348 vss.n1311 4.5005
R423 vss.n1343 vss.n1342 4.5005
R424 vss.n1341 vss.n1340 4.5005
R425 vss.n1339 vss.n1338 4.5005
R426 vss.n1337 vss.n1313 4.5005
R427 vss.n1333 vss.n1332 4.5005
R428 vss.n1331 vss.n1330 4.5005
R429 vss.n1329 vss.n1328 4.5005
R430 vss.n1327 vss.n1315 4.5005
R431 vss.n1323 vss.n1322 4.5005
R432 vss.n1321 vss.n1320 4.5005
R433 vss.n1319 vss.n1318 4.5005
R434 vss.n1232 vss.n1228 4.5005
R435 vss.n1236 vss.n1235 4.5005
R436 vss.n1237 vss.n1227 4.5005
R437 vss.n1241 vss.n1238 4.5005
R438 vss.n1242 vss.n1226 4.5005
R439 vss.n1246 vss.n1245 4.5005
R440 vss.n1247 vss.n1225 4.5005
R441 vss.n1251 vss.n1248 4.5005
R442 vss.n1252 vss.n1224 4.5005
R443 vss.n1256 vss.n1255 4.5005
R444 vss.n1257 vss.n1223 4.5005
R445 vss.n1262 vss.n1259 4.5005
R446 vss.n1263 vss.n1222 4.5005
R447 vss.n1267 vss.n1266 4.5005
R448 vss.n1268 vss.n1221 4.5005
R449 vss.n1272 vss.n1269 4.5005
R450 vss.n1273 vss.n1220 4.5005
R451 vss.n1277 vss.n1276 4.5005
R452 vss.n1278 vss.n1219 4.5005
R453 vss.n1282 vss.n1279 4.5005
R454 vss.n1283 vss.n1218 4.5005
R455 vss.n1287 vss.n1286 4.5005
R456 vss.n1217 vss.n1216 4.5005
R457 vss.n1286 vss.n1285 4.5005
R458 vss.n1284 vss.n1283 4.5005
R459 vss.n1282 vss.n1281 4.5005
R460 vss.n1280 vss.n1219 4.5005
R461 vss.n1276 vss.n1275 4.5005
R462 vss.n1274 vss.n1273 4.5005
R463 vss.n1272 vss.n1271 4.5005
R464 vss.n1270 vss.n1221 4.5005
R465 vss.n1266 vss.n1265 4.5005
R466 vss.n1264 vss.n1263 4.5005
R467 vss.n1262 vss.n1261 4.5005
R468 vss.n1260 vss.n1223 4.5005
R469 vss.n1255 vss.n1254 4.5005
R470 vss.n1253 vss.n1252 4.5005
R471 vss.n1251 vss.n1250 4.5005
R472 vss.n1249 vss.n1225 4.5005
R473 vss.n1245 vss.n1244 4.5005
R474 vss.n1243 vss.n1242 4.5005
R475 vss.n1241 vss.n1240 4.5005
R476 vss.n1239 vss.n1227 4.5005
R477 vss.n1235 vss.n1234 4.5005
R478 vss.n1233 vss.n1232 4.5005
R479 vss.n1231 vss.n1230 4.5005
R480 vss.n1144 vss.n1140 4.5005
R481 vss.n1148 vss.n1147 4.5005
R482 vss.n1149 vss.n1139 4.5005
R483 vss.n1153 vss.n1150 4.5005
R484 vss.n1154 vss.n1138 4.5005
R485 vss.n1158 vss.n1157 4.5005
R486 vss.n1159 vss.n1137 4.5005
R487 vss.n1163 vss.n1160 4.5005
R488 vss.n1164 vss.n1136 4.5005
R489 vss.n1168 vss.n1167 4.5005
R490 vss.n1169 vss.n1135 4.5005
R491 vss.n1174 vss.n1171 4.5005
R492 vss.n1175 vss.n1134 4.5005
R493 vss.n1179 vss.n1178 4.5005
R494 vss.n1180 vss.n1133 4.5005
R495 vss.n1184 vss.n1181 4.5005
R496 vss.n1185 vss.n1132 4.5005
R497 vss.n1189 vss.n1188 4.5005
R498 vss.n1190 vss.n1131 4.5005
R499 vss.n1194 vss.n1191 4.5005
R500 vss.n1195 vss.n1130 4.5005
R501 vss.n1199 vss.n1198 4.5005
R502 vss.n1129 vss.n1128 4.5005
R503 vss.n1198 vss.n1197 4.5005
R504 vss.n1196 vss.n1195 4.5005
R505 vss.n1194 vss.n1193 4.5005
R506 vss.n1192 vss.n1131 4.5005
R507 vss.n1188 vss.n1187 4.5005
R508 vss.n1186 vss.n1185 4.5005
R509 vss.n1184 vss.n1183 4.5005
R510 vss.n1182 vss.n1133 4.5005
R511 vss.n1178 vss.n1177 4.5005
R512 vss.n1176 vss.n1175 4.5005
R513 vss.n1174 vss.n1173 4.5005
R514 vss.n1172 vss.n1135 4.5005
R515 vss.n1167 vss.n1166 4.5005
R516 vss.n1165 vss.n1164 4.5005
R517 vss.n1163 vss.n1162 4.5005
R518 vss.n1161 vss.n1137 4.5005
R519 vss.n1157 vss.n1156 4.5005
R520 vss.n1155 vss.n1154 4.5005
R521 vss.n1153 vss.n1152 4.5005
R522 vss.n1151 vss.n1139 4.5005
R523 vss.n1147 vss.n1146 4.5005
R524 vss.n1145 vss.n1144 4.5005
R525 vss.n1143 vss.n1142 4.5005
R526 vss.n1056 vss.n1052 4.5005
R527 vss.n1060 vss.n1059 4.5005
R528 vss.n1061 vss.n1051 4.5005
R529 vss.n1065 vss.n1062 4.5005
R530 vss.n1066 vss.n1050 4.5005
R531 vss.n1070 vss.n1069 4.5005
R532 vss.n1071 vss.n1049 4.5005
R533 vss.n1075 vss.n1072 4.5005
R534 vss.n1076 vss.n1048 4.5005
R535 vss.n1080 vss.n1079 4.5005
R536 vss.n1081 vss.n1047 4.5005
R537 vss.n1086 vss.n1083 4.5005
R538 vss.n1087 vss.n1046 4.5005
R539 vss.n1091 vss.n1090 4.5005
R540 vss.n1092 vss.n1045 4.5005
R541 vss.n1096 vss.n1093 4.5005
R542 vss.n1097 vss.n1044 4.5005
R543 vss.n1101 vss.n1100 4.5005
R544 vss.n1102 vss.n1043 4.5005
R545 vss.n1106 vss.n1103 4.5005
R546 vss.n1107 vss.n1042 4.5005
R547 vss.n1111 vss.n1110 4.5005
R548 vss.n1041 vss.n1040 4.5005
R549 vss.n1110 vss.n1109 4.5005
R550 vss.n1108 vss.n1107 4.5005
R551 vss.n1106 vss.n1105 4.5005
R552 vss.n1104 vss.n1043 4.5005
R553 vss.n1100 vss.n1099 4.5005
R554 vss.n1098 vss.n1097 4.5005
R555 vss.n1096 vss.n1095 4.5005
R556 vss.n1094 vss.n1045 4.5005
R557 vss.n1090 vss.n1089 4.5005
R558 vss.n1088 vss.n1087 4.5005
R559 vss.n1086 vss.n1085 4.5005
R560 vss.n1084 vss.n1047 4.5005
R561 vss.n1079 vss.n1078 4.5005
R562 vss.n1077 vss.n1076 4.5005
R563 vss.n1075 vss.n1074 4.5005
R564 vss.n1073 vss.n1049 4.5005
R565 vss.n1069 vss.n1068 4.5005
R566 vss.n1067 vss.n1066 4.5005
R567 vss.n1065 vss.n1064 4.5005
R568 vss.n1063 vss.n1051 4.5005
R569 vss.n1059 vss.n1058 4.5005
R570 vss.n1057 vss.n1056 4.5005
R571 vss.n1055 vss.n1054 4.5005
R572 vss.n968 vss.n964 4.5005
R573 vss.n972 vss.n971 4.5005
R574 vss.n973 vss.n963 4.5005
R575 vss.n977 vss.n974 4.5005
R576 vss.n978 vss.n962 4.5005
R577 vss.n982 vss.n981 4.5005
R578 vss.n983 vss.n961 4.5005
R579 vss.n987 vss.n984 4.5005
R580 vss.n988 vss.n960 4.5005
R581 vss.n992 vss.n991 4.5005
R582 vss.n993 vss.n959 4.5005
R583 vss.n998 vss.n995 4.5005
R584 vss.n999 vss.n958 4.5005
R585 vss.n1003 vss.n1002 4.5005
R586 vss.n1004 vss.n957 4.5005
R587 vss.n1008 vss.n1005 4.5005
R588 vss.n1009 vss.n956 4.5005
R589 vss.n1013 vss.n1012 4.5005
R590 vss.n1014 vss.n955 4.5005
R591 vss.n1018 vss.n1015 4.5005
R592 vss.n1019 vss.n954 4.5005
R593 vss.n1023 vss.n1022 4.5005
R594 vss.n953 vss.n952 4.5005
R595 vss.n1022 vss.n1021 4.5005
R596 vss.n1020 vss.n1019 4.5005
R597 vss.n1018 vss.n1017 4.5005
R598 vss.n1016 vss.n955 4.5005
R599 vss.n1012 vss.n1011 4.5005
R600 vss.n1010 vss.n1009 4.5005
R601 vss.n1008 vss.n1007 4.5005
R602 vss.n1006 vss.n957 4.5005
R603 vss.n1002 vss.n1001 4.5005
R604 vss.n1000 vss.n999 4.5005
R605 vss.n998 vss.n997 4.5005
R606 vss.n996 vss.n959 4.5005
R607 vss.n991 vss.n990 4.5005
R608 vss.n989 vss.n988 4.5005
R609 vss.n987 vss.n986 4.5005
R610 vss.n985 vss.n961 4.5005
R611 vss.n981 vss.n980 4.5005
R612 vss.n979 vss.n978 4.5005
R613 vss.n977 vss.n976 4.5005
R614 vss.n975 vss.n963 4.5005
R615 vss.n971 vss.n970 4.5005
R616 vss.n969 vss.n968 4.5005
R617 vss.n967 vss.n966 4.5005
R618 vss.n880 vss.n876 4.5005
R619 vss.n884 vss.n883 4.5005
R620 vss.n885 vss.n875 4.5005
R621 vss.n889 vss.n886 4.5005
R622 vss.n890 vss.n874 4.5005
R623 vss.n894 vss.n893 4.5005
R624 vss.n895 vss.n873 4.5005
R625 vss.n899 vss.n896 4.5005
R626 vss.n900 vss.n872 4.5005
R627 vss.n904 vss.n903 4.5005
R628 vss.n905 vss.n871 4.5005
R629 vss.n910 vss.n907 4.5005
R630 vss.n911 vss.n870 4.5005
R631 vss.n915 vss.n914 4.5005
R632 vss.n916 vss.n869 4.5005
R633 vss.n920 vss.n917 4.5005
R634 vss.n921 vss.n868 4.5005
R635 vss.n925 vss.n924 4.5005
R636 vss.n926 vss.n867 4.5005
R637 vss.n930 vss.n927 4.5005
R638 vss.n931 vss.n866 4.5005
R639 vss.n935 vss.n934 4.5005
R640 vss.n865 vss.n864 4.5005
R641 vss.n934 vss.n933 4.5005
R642 vss.n932 vss.n931 4.5005
R643 vss.n930 vss.n929 4.5005
R644 vss.n928 vss.n867 4.5005
R645 vss.n924 vss.n923 4.5005
R646 vss.n922 vss.n921 4.5005
R647 vss.n920 vss.n919 4.5005
R648 vss.n918 vss.n869 4.5005
R649 vss.n914 vss.n913 4.5005
R650 vss.n912 vss.n911 4.5005
R651 vss.n910 vss.n909 4.5005
R652 vss.n908 vss.n871 4.5005
R653 vss.n903 vss.n902 4.5005
R654 vss.n901 vss.n900 4.5005
R655 vss.n899 vss.n898 4.5005
R656 vss.n897 vss.n873 4.5005
R657 vss.n893 vss.n892 4.5005
R658 vss.n891 vss.n890 4.5005
R659 vss.n889 vss.n888 4.5005
R660 vss.n887 vss.n875 4.5005
R661 vss.n883 vss.n882 4.5005
R662 vss.n881 vss.n880 4.5005
R663 vss.n879 vss.n878 4.5005
R664 vss.n792 vss.n788 4.5005
R665 vss.n796 vss.n795 4.5005
R666 vss.n797 vss.n787 4.5005
R667 vss.n801 vss.n798 4.5005
R668 vss.n802 vss.n786 4.5005
R669 vss.n806 vss.n805 4.5005
R670 vss.n807 vss.n785 4.5005
R671 vss.n811 vss.n808 4.5005
R672 vss.n812 vss.n784 4.5005
R673 vss.n816 vss.n815 4.5005
R674 vss.n817 vss.n783 4.5005
R675 vss.n822 vss.n819 4.5005
R676 vss.n823 vss.n782 4.5005
R677 vss.n827 vss.n826 4.5005
R678 vss.n828 vss.n781 4.5005
R679 vss.n832 vss.n829 4.5005
R680 vss.n833 vss.n780 4.5005
R681 vss.n837 vss.n836 4.5005
R682 vss.n838 vss.n779 4.5005
R683 vss.n842 vss.n839 4.5005
R684 vss.n843 vss.n778 4.5005
R685 vss.n847 vss.n846 4.5005
R686 vss.n777 vss.n776 4.5005
R687 vss.n846 vss.n845 4.5005
R688 vss.n844 vss.n843 4.5005
R689 vss.n842 vss.n841 4.5005
R690 vss.n840 vss.n779 4.5005
R691 vss.n836 vss.n835 4.5005
R692 vss.n834 vss.n833 4.5005
R693 vss.n832 vss.n831 4.5005
R694 vss.n830 vss.n781 4.5005
R695 vss.n826 vss.n825 4.5005
R696 vss.n824 vss.n823 4.5005
R697 vss.n822 vss.n821 4.5005
R698 vss.n820 vss.n783 4.5005
R699 vss.n815 vss.n814 4.5005
R700 vss.n813 vss.n812 4.5005
R701 vss.n811 vss.n810 4.5005
R702 vss.n809 vss.n785 4.5005
R703 vss.n805 vss.n804 4.5005
R704 vss.n803 vss.n802 4.5005
R705 vss.n801 vss.n800 4.5005
R706 vss.n799 vss.n787 4.5005
R707 vss.n795 vss.n794 4.5005
R708 vss.n793 vss.n792 4.5005
R709 vss.n791 vss.n790 4.5005
R710 vss.n704 vss.n700 4.5005
R711 vss.n708 vss.n707 4.5005
R712 vss.n709 vss.n699 4.5005
R713 vss.n713 vss.n710 4.5005
R714 vss.n714 vss.n698 4.5005
R715 vss.n718 vss.n717 4.5005
R716 vss.n719 vss.n697 4.5005
R717 vss.n723 vss.n720 4.5005
R718 vss.n724 vss.n696 4.5005
R719 vss.n728 vss.n727 4.5005
R720 vss.n729 vss.n695 4.5005
R721 vss.n734 vss.n731 4.5005
R722 vss.n735 vss.n694 4.5005
R723 vss.n739 vss.n738 4.5005
R724 vss.n740 vss.n693 4.5005
R725 vss.n744 vss.n741 4.5005
R726 vss.n745 vss.n692 4.5005
R727 vss.n749 vss.n748 4.5005
R728 vss.n750 vss.n691 4.5005
R729 vss.n754 vss.n751 4.5005
R730 vss.n755 vss.n690 4.5005
R731 vss.n759 vss.n758 4.5005
R732 vss.n689 vss.n688 4.5005
R733 vss.n758 vss.n757 4.5005
R734 vss.n756 vss.n755 4.5005
R735 vss.n754 vss.n753 4.5005
R736 vss.n752 vss.n691 4.5005
R737 vss.n748 vss.n747 4.5005
R738 vss.n746 vss.n745 4.5005
R739 vss.n744 vss.n743 4.5005
R740 vss.n742 vss.n693 4.5005
R741 vss.n738 vss.n737 4.5005
R742 vss.n736 vss.n735 4.5005
R743 vss.n734 vss.n733 4.5005
R744 vss.n732 vss.n695 4.5005
R745 vss.n727 vss.n726 4.5005
R746 vss.n725 vss.n724 4.5005
R747 vss.n723 vss.n722 4.5005
R748 vss.n721 vss.n697 4.5005
R749 vss.n717 vss.n716 4.5005
R750 vss.n715 vss.n714 4.5005
R751 vss.n713 vss.n712 4.5005
R752 vss.n711 vss.n699 4.5005
R753 vss.n707 vss.n706 4.5005
R754 vss.n705 vss.n704 4.5005
R755 vss.n703 vss.n702 4.5005
R756 vss.n616 vss.n612 4.5005
R757 vss.n620 vss.n619 4.5005
R758 vss.n621 vss.n611 4.5005
R759 vss.n625 vss.n622 4.5005
R760 vss.n626 vss.n610 4.5005
R761 vss.n630 vss.n629 4.5005
R762 vss.n631 vss.n609 4.5005
R763 vss.n635 vss.n632 4.5005
R764 vss.n636 vss.n608 4.5005
R765 vss.n640 vss.n639 4.5005
R766 vss.n641 vss.n607 4.5005
R767 vss.n646 vss.n643 4.5005
R768 vss.n647 vss.n606 4.5005
R769 vss.n651 vss.n650 4.5005
R770 vss.n652 vss.n605 4.5005
R771 vss.n656 vss.n653 4.5005
R772 vss.n657 vss.n604 4.5005
R773 vss.n661 vss.n660 4.5005
R774 vss.n662 vss.n603 4.5005
R775 vss.n666 vss.n663 4.5005
R776 vss.n667 vss.n602 4.5005
R777 vss.n671 vss.n670 4.5005
R778 vss.n601 vss.n600 4.5005
R779 vss.n670 vss.n669 4.5005
R780 vss.n668 vss.n667 4.5005
R781 vss.n666 vss.n665 4.5005
R782 vss.n664 vss.n603 4.5005
R783 vss.n660 vss.n659 4.5005
R784 vss.n658 vss.n657 4.5005
R785 vss.n656 vss.n655 4.5005
R786 vss.n654 vss.n605 4.5005
R787 vss.n650 vss.n649 4.5005
R788 vss.n648 vss.n647 4.5005
R789 vss.n646 vss.n645 4.5005
R790 vss.n644 vss.n607 4.5005
R791 vss.n639 vss.n638 4.5005
R792 vss.n637 vss.n636 4.5005
R793 vss.n635 vss.n634 4.5005
R794 vss.n633 vss.n609 4.5005
R795 vss.n629 vss.n628 4.5005
R796 vss.n627 vss.n626 4.5005
R797 vss.n625 vss.n624 4.5005
R798 vss.n623 vss.n611 4.5005
R799 vss.n619 vss.n618 4.5005
R800 vss.n617 vss.n616 4.5005
R801 vss.n615 vss.n614 4.5005
R802 vss.n528 vss.n524 4.5005
R803 vss.n532 vss.n531 4.5005
R804 vss.n533 vss.n523 4.5005
R805 vss.n537 vss.n534 4.5005
R806 vss.n538 vss.n522 4.5005
R807 vss.n542 vss.n541 4.5005
R808 vss.n543 vss.n521 4.5005
R809 vss.n547 vss.n544 4.5005
R810 vss.n548 vss.n520 4.5005
R811 vss.n552 vss.n551 4.5005
R812 vss.n553 vss.n519 4.5005
R813 vss.n558 vss.n555 4.5005
R814 vss.n559 vss.n518 4.5005
R815 vss.n563 vss.n562 4.5005
R816 vss.n564 vss.n517 4.5005
R817 vss.n568 vss.n565 4.5005
R818 vss.n569 vss.n516 4.5005
R819 vss.n573 vss.n572 4.5005
R820 vss.n574 vss.n515 4.5005
R821 vss.n578 vss.n575 4.5005
R822 vss.n579 vss.n514 4.5005
R823 vss.n583 vss.n582 4.5005
R824 vss.n513 vss.n512 4.5005
R825 vss.n582 vss.n581 4.5005
R826 vss.n580 vss.n579 4.5005
R827 vss.n578 vss.n577 4.5005
R828 vss.n576 vss.n515 4.5005
R829 vss.n572 vss.n571 4.5005
R830 vss.n570 vss.n569 4.5005
R831 vss.n568 vss.n567 4.5005
R832 vss.n566 vss.n517 4.5005
R833 vss.n562 vss.n561 4.5005
R834 vss.n560 vss.n559 4.5005
R835 vss.n558 vss.n557 4.5005
R836 vss.n556 vss.n519 4.5005
R837 vss.n551 vss.n550 4.5005
R838 vss.n549 vss.n548 4.5005
R839 vss.n547 vss.n546 4.5005
R840 vss.n545 vss.n521 4.5005
R841 vss.n541 vss.n540 4.5005
R842 vss.n539 vss.n538 4.5005
R843 vss.n537 vss.n536 4.5005
R844 vss.n535 vss.n523 4.5005
R845 vss.n531 vss.n530 4.5005
R846 vss.n529 vss.n528 4.5005
R847 vss.n527 vss.n526 4.5005
R848 vss.n440 vss.n436 4.5005
R849 vss.n444 vss.n443 4.5005
R850 vss.n445 vss.n435 4.5005
R851 vss.n449 vss.n446 4.5005
R852 vss.n450 vss.n434 4.5005
R853 vss.n454 vss.n453 4.5005
R854 vss.n455 vss.n433 4.5005
R855 vss.n459 vss.n456 4.5005
R856 vss.n460 vss.n432 4.5005
R857 vss.n464 vss.n463 4.5005
R858 vss.n465 vss.n431 4.5005
R859 vss.n470 vss.n467 4.5005
R860 vss.n471 vss.n430 4.5005
R861 vss.n475 vss.n474 4.5005
R862 vss.n476 vss.n429 4.5005
R863 vss.n480 vss.n477 4.5005
R864 vss.n481 vss.n428 4.5005
R865 vss.n485 vss.n484 4.5005
R866 vss.n486 vss.n427 4.5005
R867 vss.n490 vss.n487 4.5005
R868 vss.n491 vss.n426 4.5005
R869 vss.n495 vss.n494 4.5005
R870 vss.n425 vss.n424 4.5005
R871 vss.n494 vss.n493 4.5005
R872 vss.n492 vss.n491 4.5005
R873 vss.n490 vss.n489 4.5005
R874 vss.n488 vss.n427 4.5005
R875 vss.n484 vss.n483 4.5005
R876 vss.n482 vss.n481 4.5005
R877 vss.n480 vss.n479 4.5005
R878 vss.n478 vss.n429 4.5005
R879 vss.n474 vss.n473 4.5005
R880 vss.n472 vss.n471 4.5005
R881 vss.n470 vss.n469 4.5005
R882 vss.n468 vss.n431 4.5005
R883 vss.n463 vss.n462 4.5005
R884 vss.n461 vss.n460 4.5005
R885 vss.n459 vss.n458 4.5005
R886 vss.n457 vss.n433 4.5005
R887 vss.n453 vss.n452 4.5005
R888 vss.n451 vss.n450 4.5005
R889 vss.n449 vss.n448 4.5005
R890 vss.n447 vss.n435 4.5005
R891 vss.n443 vss.n442 4.5005
R892 vss.n441 vss.n440 4.5005
R893 vss.n439 vss.n438 4.5005
R894 vss.n352 vss.n348 4.5005
R895 vss.n356 vss.n355 4.5005
R896 vss.n357 vss.n347 4.5005
R897 vss.n361 vss.n358 4.5005
R898 vss.n362 vss.n346 4.5005
R899 vss.n366 vss.n365 4.5005
R900 vss.n367 vss.n345 4.5005
R901 vss.n371 vss.n368 4.5005
R902 vss.n372 vss.n344 4.5005
R903 vss.n376 vss.n375 4.5005
R904 vss.n377 vss.n343 4.5005
R905 vss.n382 vss.n379 4.5005
R906 vss.n383 vss.n342 4.5005
R907 vss.n387 vss.n386 4.5005
R908 vss.n388 vss.n341 4.5005
R909 vss.n392 vss.n389 4.5005
R910 vss.n393 vss.n340 4.5005
R911 vss.n397 vss.n396 4.5005
R912 vss.n398 vss.n339 4.5005
R913 vss.n402 vss.n399 4.5005
R914 vss.n403 vss.n338 4.5005
R915 vss.n407 vss.n406 4.5005
R916 vss.n337 vss.n336 4.5005
R917 vss.n406 vss.n405 4.5005
R918 vss.n404 vss.n403 4.5005
R919 vss.n402 vss.n401 4.5005
R920 vss.n400 vss.n339 4.5005
R921 vss.n396 vss.n395 4.5005
R922 vss.n394 vss.n393 4.5005
R923 vss.n392 vss.n391 4.5005
R924 vss.n390 vss.n341 4.5005
R925 vss.n386 vss.n385 4.5005
R926 vss.n384 vss.n383 4.5005
R927 vss.n382 vss.n381 4.5005
R928 vss.n380 vss.n343 4.5005
R929 vss.n375 vss.n374 4.5005
R930 vss.n373 vss.n372 4.5005
R931 vss.n371 vss.n370 4.5005
R932 vss.n369 vss.n345 4.5005
R933 vss.n365 vss.n364 4.5005
R934 vss.n363 vss.n362 4.5005
R935 vss.n361 vss.n360 4.5005
R936 vss.n359 vss.n347 4.5005
R937 vss.n355 vss.n354 4.5005
R938 vss.n353 vss.n352 4.5005
R939 vss.n351 vss.n350 4.5005
R940 vss.n264 vss.n260 4.5005
R941 vss.n268 vss.n267 4.5005
R942 vss.n269 vss.n259 4.5005
R943 vss.n273 vss.n270 4.5005
R944 vss.n274 vss.n258 4.5005
R945 vss.n278 vss.n277 4.5005
R946 vss.n279 vss.n257 4.5005
R947 vss.n283 vss.n280 4.5005
R948 vss.n284 vss.n256 4.5005
R949 vss.n288 vss.n287 4.5005
R950 vss.n289 vss.n255 4.5005
R951 vss.n294 vss.n291 4.5005
R952 vss.n295 vss.n254 4.5005
R953 vss.n299 vss.n298 4.5005
R954 vss.n300 vss.n253 4.5005
R955 vss.n304 vss.n301 4.5005
R956 vss.n305 vss.n252 4.5005
R957 vss.n309 vss.n308 4.5005
R958 vss.n310 vss.n251 4.5005
R959 vss.n314 vss.n311 4.5005
R960 vss.n315 vss.n250 4.5005
R961 vss.n319 vss.n318 4.5005
R962 vss.n249 vss.n248 4.5005
R963 vss.n318 vss.n317 4.5005
R964 vss.n316 vss.n315 4.5005
R965 vss.n314 vss.n313 4.5005
R966 vss.n312 vss.n251 4.5005
R967 vss.n308 vss.n307 4.5005
R968 vss.n306 vss.n305 4.5005
R969 vss.n304 vss.n303 4.5005
R970 vss.n302 vss.n253 4.5005
R971 vss.n298 vss.n297 4.5005
R972 vss.n296 vss.n295 4.5005
R973 vss.n294 vss.n293 4.5005
R974 vss.n292 vss.n255 4.5005
R975 vss.n287 vss.n286 4.5005
R976 vss.n285 vss.n284 4.5005
R977 vss.n283 vss.n282 4.5005
R978 vss.n281 vss.n257 4.5005
R979 vss.n277 vss.n276 4.5005
R980 vss.n275 vss.n274 4.5005
R981 vss.n273 vss.n272 4.5005
R982 vss.n271 vss.n259 4.5005
R983 vss.n267 vss.n266 4.5005
R984 vss.n265 vss.n264 4.5005
R985 vss.n263 vss.n262 4.5005
R986 vss.n176 vss.n172 4.5005
R987 vss.n180 vss.n179 4.5005
R988 vss.n181 vss.n171 4.5005
R989 vss.n185 vss.n182 4.5005
R990 vss.n186 vss.n170 4.5005
R991 vss.n190 vss.n189 4.5005
R992 vss.n191 vss.n169 4.5005
R993 vss.n195 vss.n192 4.5005
R994 vss.n196 vss.n168 4.5005
R995 vss.n200 vss.n199 4.5005
R996 vss.n201 vss.n167 4.5005
R997 vss.n206 vss.n203 4.5005
R998 vss.n207 vss.n166 4.5005
R999 vss.n211 vss.n210 4.5005
R1000 vss.n212 vss.n165 4.5005
R1001 vss.n216 vss.n213 4.5005
R1002 vss.n217 vss.n164 4.5005
R1003 vss.n221 vss.n220 4.5005
R1004 vss.n222 vss.n163 4.5005
R1005 vss.n226 vss.n223 4.5005
R1006 vss.n227 vss.n162 4.5005
R1007 vss.n231 vss.n230 4.5005
R1008 vss.n161 vss.n160 4.5005
R1009 vss.n230 vss.n229 4.5005
R1010 vss.n228 vss.n227 4.5005
R1011 vss.n226 vss.n225 4.5005
R1012 vss.n224 vss.n163 4.5005
R1013 vss.n220 vss.n219 4.5005
R1014 vss.n218 vss.n217 4.5005
R1015 vss.n216 vss.n215 4.5005
R1016 vss.n214 vss.n165 4.5005
R1017 vss.n210 vss.n209 4.5005
R1018 vss.n208 vss.n207 4.5005
R1019 vss.n206 vss.n205 4.5005
R1020 vss.n204 vss.n167 4.5005
R1021 vss.n199 vss.n198 4.5005
R1022 vss.n197 vss.n196 4.5005
R1023 vss.n195 vss.n194 4.5005
R1024 vss.n193 vss.n169 4.5005
R1025 vss.n189 vss.n188 4.5005
R1026 vss.n187 vss.n186 4.5005
R1027 vss.n185 vss.n184 4.5005
R1028 vss.n183 vss.n171 4.5005
R1029 vss.n179 vss.n178 4.5005
R1030 vss.n177 vss.n176 4.5005
R1031 vss.n175 vss.n174 4.5005
R1032 vss.n234 vss.n147 4.5005
R1033 vss.n234 vss.n233 4.5005
R1034 vss.n322 vss.n235 4.5005
R1035 vss.n322 vss.n321 4.5005
R1036 vss.n410 vss.n323 4.5005
R1037 vss.n410 vss.n409 4.5005
R1038 vss.n498 vss.n411 4.5005
R1039 vss.n498 vss.n497 4.5005
R1040 vss.n586 vss.n499 4.5005
R1041 vss.n586 vss.n585 4.5005
R1042 vss.n674 vss.n587 4.5005
R1043 vss.n674 vss.n673 4.5005
R1044 vss.n762 vss.n675 4.5005
R1045 vss.n762 vss.n761 4.5005
R1046 vss.n850 vss.n763 4.5005
R1047 vss.n850 vss.n849 4.5005
R1048 vss.n938 vss.n851 4.5005
R1049 vss.n938 vss.n937 4.5005
R1050 vss.n1026 vss.n939 4.5005
R1051 vss.n1026 vss.n1025 4.5005
R1052 vss.n1114 vss.n1027 4.5005
R1053 vss.n1114 vss.n1113 4.5005
R1054 vss.n1202 vss.n1115 4.5005
R1055 vss.n1202 vss.n1201 4.5005
R1056 vss.n1290 vss.n1203 4.5005
R1057 vss.n1290 vss.n1289 4.5005
R1058 vss.n1378 vss.n1291 4.5005
R1059 vss.n1378 vss.n1377 4.5005
R1060 vss.n1466 vss.n1379 4.5005
R1061 vss.n1466 vss.n1465 4.5005
R1062 vss.n1554 vss.n1467 4.5005
R1063 vss.n1554 vss.n1553 4.5005
R1064 vss.n2319 vss.n2318 4.5005
R1065 vss.n2317 vss.n146 4.5005
R1066 vss.n2223 vss.n2219 4.5005
R1067 vss.n2227 vss.n2226 4.5005
R1068 vss.n2228 vss.n2218 4.5005
R1069 vss.n2232 vss.n2229 4.5005
R1070 vss.n2233 vss.n2217 4.5005
R1071 vss.n2237 vss.n2236 4.5005
R1072 vss.n2238 vss.n2216 4.5005
R1073 vss.n2242 vss.n2239 4.5005
R1074 vss.n2243 vss.n2215 4.5005
R1075 vss.n2247 vss.n2246 4.5005
R1076 vss.n2248 vss.n2214 4.5005
R1077 vss.n2253 vss.n2250 4.5005
R1078 vss.n2254 vss.n2213 4.5005
R1079 vss.n2258 vss.n2257 4.5005
R1080 vss.n2259 vss.n2212 4.5005
R1081 vss.n2263 vss.n2260 4.5005
R1082 vss.n2264 vss.n2211 4.5005
R1083 vss.n2268 vss.n2267 4.5005
R1084 vss.n2269 vss.n2210 4.5005
R1085 vss.n2273 vss.n2270 4.5005
R1086 vss.n2274 vss.n2209 4.5005
R1087 vss.n2278 vss.n2277 4.5005
R1088 vss.n2208 vss.n2207 4.5005
R1089 vss.n2277 vss.n2276 4.5005
R1090 vss.n2275 vss.n2274 4.5005
R1091 vss.n2273 vss.n2272 4.5005
R1092 vss.n2271 vss.n2210 4.5005
R1093 vss.n2267 vss.n2266 4.5005
R1094 vss.n2265 vss.n2264 4.5005
R1095 vss.n2263 vss.n2262 4.5005
R1096 vss.n2261 vss.n2212 4.5005
R1097 vss.n2257 vss.n2256 4.5005
R1098 vss.n2255 vss.n2254 4.5005
R1099 vss.n2253 vss.n2252 4.5005
R1100 vss.n2251 vss.n2214 4.5005
R1101 vss.n2246 vss.n2245 4.5005
R1102 vss.n2244 vss.n2243 4.5005
R1103 vss.n2242 vss.n2241 4.5005
R1104 vss.n2240 vss.n2216 4.5005
R1105 vss.n2236 vss.n2235 4.5005
R1106 vss.n2234 vss.n2233 4.5005
R1107 vss.n2232 vss.n2231 4.5005
R1108 vss.n2230 vss.n2218 4.5005
R1109 vss.n2226 vss.n2225 4.5005
R1110 vss.n2224 vss.n2223 4.5005
R1111 vss.n2222 vss.n2221 4.5005
R1112 vss.n2135 vss.n2131 4.5005
R1113 vss.n2139 vss.n2138 4.5005
R1114 vss.n2140 vss.n2130 4.5005
R1115 vss.n2144 vss.n2141 4.5005
R1116 vss.n2145 vss.n2129 4.5005
R1117 vss.n2149 vss.n2148 4.5005
R1118 vss.n2150 vss.n2128 4.5005
R1119 vss.n2154 vss.n2151 4.5005
R1120 vss.n2155 vss.n2127 4.5005
R1121 vss.n2159 vss.n2158 4.5005
R1122 vss.n2160 vss.n2126 4.5005
R1123 vss.n2165 vss.n2162 4.5005
R1124 vss.n2166 vss.n2125 4.5005
R1125 vss.n2170 vss.n2169 4.5005
R1126 vss.n2171 vss.n2124 4.5005
R1127 vss.n2175 vss.n2172 4.5005
R1128 vss.n2176 vss.n2123 4.5005
R1129 vss.n2180 vss.n2179 4.5005
R1130 vss.n2181 vss.n2122 4.5005
R1131 vss.n2185 vss.n2182 4.5005
R1132 vss.n2186 vss.n2121 4.5005
R1133 vss.n2190 vss.n2189 4.5005
R1134 vss.n2120 vss.n2119 4.5005
R1135 vss.n2189 vss.n2188 4.5005
R1136 vss.n2187 vss.n2186 4.5005
R1137 vss.n2185 vss.n2184 4.5005
R1138 vss.n2183 vss.n2122 4.5005
R1139 vss.n2179 vss.n2178 4.5005
R1140 vss.n2177 vss.n2176 4.5005
R1141 vss.n2175 vss.n2174 4.5005
R1142 vss.n2173 vss.n2124 4.5005
R1143 vss.n2169 vss.n2168 4.5005
R1144 vss.n2167 vss.n2166 4.5005
R1145 vss.n2165 vss.n2164 4.5005
R1146 vss.n2163 vss.n2126 4.5005
R1147 vss.n2158 vss.n2157 4.5005
R1148 vss.n2156 vss.n2155 4.5005
R1149 vss.n2154 vss.n2153 4.5005
R1150 vss.n2152 vss.n2128 4.5005
R1151 vss.n2148 vss.n2147 4.5005
R1152 vss.n2146 vss.n2145 4.5005
R1153 vss.n2144 vss.n2143 4.5005
R1154 vss.n2142 vss.n2130 4.5005
R1155 vss.n2138 vss.n2137 4.5005
R1156 vss.n2136 vss.n2135 4.5005
R1157 vss.n2134 vss.n2133 4.5005
R1158 vss.n2047 vss.n2043 4.5005
R1159 vss.n2051 vss.n2050 4.5005
R1160 vss.n2052 vss.n2042 4.5005
R1161 vss.n2056 vss.n2053 4.5005
R1162 vss.n2057 vss.n2041 4.5005
R1163 vss.n2061 vss.n2060 4.5005
R1164 vss.n2062 vss.n2040 4.5005
R1165 vss.n2066 vss.n2063 4.5005
R1166 vss.n2067 vss.n2039 4.5005
R1167 vss.n2071 vss.n2070 4.5005
R1168 vss.n2072 vss.n2038 4.5005
R1169 vss.n2077 vss.n2074 4.5005
R1170 vss.n2078 vss.n2037 4.5005
R1171 vss.n2082 vss.n2081 4.5005
R1172 vss.n2083 vss.n2036 4.5005
R1173 vss.n2087 vss.n2084 4.5005
R1174 vss.n2088 vss.n2035 4.5005
R1175 vss.n2092 vss.n2091 4.5005
R1176 vss.n2093 vss.n2034 4.5005
R1177 vss.n2097 vss.n2094 4.5005
R1178 vss.n2098 vss.n2033 4.5005
R1179 vss.n2102 vss.n2101 4.5005
R1180 vss.n2032 vss.n2031 4.5005
R1181 vss.n2101 vss.n2100 4.5005
R1182 vss.n2099 vss.n2098 4.5005
R1183 vss.n2097 vss.n2096 4.5005
R1184 vss.n2095 vss.n2034 4.5005
R1185 vss.n2091 vss.n2090 4.5005
R1186 vss.n2089 vss.n2088 4.5005
R1187 vss.n2087 vss.n2086 4.5005
R1188 vss.n2085 vss.n2036 4.5005
R1189 vss.n2081 vss.n2080 4.5005
R1190 vss.n2079 vss.n2078 4.5005
R1191 vss.n2077 vss.n2076 4.5005
R1192 vss.n2075 vss.n2038 4.5005
R1193 vss.n2070 vss.n2069 4.5005
R1194 vss.n2068 vss.n2067 4.5005
R1195 vss.n2066 vss.n2065 4.5005
R1196 vss.n2064 vss.n2040 4.5005
R1197 vss.n2060 vss.n2059 4.5005
R1198 vss.n2058 vss.n2057 4.5005
R1199 vss.n2056 vss.n2055 4.5005
R1200 vss.n2054 vss.n2042 4.5005
R1201 vss.n2050 vss.n2049 4.5005
R1202 vss.n2048 vss.n2047 4.5005
R1203 vss.n2046 vss.n2045 4.5005
R1204 vss.n1959 vss.n1955 4.5005
R1205 vss.n1963 vss.n1962 4.5005
R1206 vss.n1964 vss.n1954 4.5005
R1207 vss.n1968 vss.n1965 4.5005
R1208 vss.n1969 vss.n1953 4.5005
R1209 vss.n1973 vss.n1972 4.5005
R1210 vss.n1974 vss.n1952 4.5005
R1211 vss.n1978 vss.n1975 4.5005
R1212 vss.n1979 vss.n1951 4.5005
R1213 vss.n1983 vss.n1982 4.5005
R1214 vss.n1984 vss.n1950 4.5005
R1215 vss.n1989 vss.n1986 4.5005
R1216 vss.n1990 vss.n1949 4.5005
R1217 vss.n1994 vss.n1993 4.5005
R1218 vss.n1995 vss.n1948 4.5005
R1219 vss.n1999 vss.n1996 4.5005
R1220 vss.n2000 vss.n1947 4.5005
R1221 vss.n2004 vss.n2003 4.5005
R1222 vss.n2005 vss.n1946 4.5005
R1223 vss.n2009 vss.n2006 4.5005
R1224 vss.n2010 vss.n1945 4.5005
R1225 vss.n2014 vss.n2013 4.5005
R1226 vss.n1944 vss.n1943 4.5005
R1227 vss.n2013 vss.n2012 4.5005
R1228 vss.n2011 vss.n2010 4.5005
R1229 vss.n2009 vss.n2008 4.5005
R1230 vss.n2007 vss.n1946 4.5005
R1231 vss.n2003 vss.n2002 4.5005
R1232 vss.n2001 vss.n2000 4.5005
R1233 vss.n1999 vss.n1998 4.5005
R1234 vss.n1997 vss.n1948 4.5005
R1235 vss.n1993 vss.n1992 4.5005
R1236 vss.n1991 vss.n1990 4.5005
R1237 vss.n1989 vss.n1988 4.5005
R1238 vss.n1987 vss.n1950 4.5005
R1239 vss.n1982 vss.n1981 4.5005
R1240 vss.n1980 vss.n1979 4.5005
R1241 vss.n1978 vss.n1977 4.5005
R1242 vss.n1976 vss.n1952 4.5005
R1243 vss.n1972 vss.n1971 4.5005
R1244 vss.n1970 vss.n1969 4.5005
R1245 vss.n1968 vss.n1967 4.5005
R1246 vss.n1966 vss.n1954 4.5005
R1247 vss.n1962 vss.n1961 4.5005
R1248 vss.n1960 vss.n1959 4.5005
R1249 vss.n1958 vss.n1957 4.5005
R1250 vss.n1871 vss.n1867 4.5005
R1251 vss.n1875 vss.n1874 4.5005
R1252 vss.n1876 vss.n1866 4.5005
R1253 vss.n1880 vss.n1877 4.5005
R1254 vss.n1881 vss.n1865 4.5005
R1255 vss.n1885 vss.n1884 4.5005
R1256 vss.n1886 vss.n1864 4.5005
R1257 vss.n1890 vss.n1887 4.5005
R1258 vss.n1891 vss.n1863 4.5005
R1259 vss.n1895 vss.n1894 4.5005
R1260 vss.n1896 vss.n1862 4.5005
R1261 vss.n1901 vss.n1898 4.5005
R1262 vss.n1902 vss.n1861 4.5005
R1263 vss.n1906 vss.n1905 4.5005
R1264 vss.n1907 vss.n1860 4.5005
R1265 vss.n1911 vss.n1908 4.5005
R1266 vss.n1912 vss.n1859 4.5005
R1267 vss.n1916 vss.n1915 4.5005
R1268 vss.n1917 vss.n1858 4.5005
R1269 vss.n1921 vss.n1918 4.5005
R1270 vss.n1922 vss.n1857 4.5005
R1271 vss.n1926 vss.n1925 4.5005
R1272 vss.n1856 vss.n1855 4.5005
R1273 vss.n1925 vss.n1924 4.5005
R1274 vss.n1923 vss.n1922 4.5005
R1275 vss.n1921 vss.n1920 4.5005
R1276 vss.n1919 vss.n1858 4.5005
R1277 vss.n1915 vss.n1914 4.5005
R1278 vss.n1913 vss.n1912 4.5005
R1279 vss.n1911 vss.n1910 4.5005
R1280 vss.n1909 vss.n1860 4.5005
R1281 vss.n1905 vss.n1904 4.5005
R1282 vss.n1903 vss.n1902 4.5005
R1283 vss.n1901 vss.n1900 4.5005
R1284 vss.n1899 vss.n1862 4.5005
R1285 vss.n1894 vss.n1893 4.5005
R1286 vss.n1892 vss.n1891 4.5005
R1287 vss.n1890 vss.n1889 4.5005
R1288 vss.n1888 vss.n1864 4.5005
R1289 vss.n1884 vss.n1883 4.5005
R1290 vss.n1882 vss.n1881 4.5005
R1291 vss.n1880 vss.n1879 4.5005
R1292 vss.n1878 vss.n1866 4.5005
R1293 vss.n1874 vss.n1873 4.5005
R1294 vss.n1872 vss.n1871 4.5005
R1295 vss.n1870 vss.n1869 4.5005
R1296 vss.n1783 vss.n1779 4.5005
R1297 vss.n1787 vss.n1786 4.5005
R1298 vss.n1788 vss.n1778 4.5005
R1299 vss.n1792 vss.n1789 4.5005
R1300 vss.n1793 vss.n1777 4.5005
R1301 vss.n1797 vss.n1796 4.5005
R1302 vss.n1798 vss.n1776 4.5005
R1303 vss.n1802 vss.n1799 4.5005
R1304 vss.n1803 vss.n1775 4.5005
R1305 vss.n1807 vss.n1806 4.5005
R1306 vss.n1808 vss.n1774 4.5005
R1307 vss.n1813 vss.n1810 4.5005
R1308 vss.n1814 vss.n1773 4.5005
R1309 vss.n1818 vss.n1817 4.5005
R1310 vss.n1819 vss.n1772 4.5005
R1311 vss.n1823 vss.n1820 4.5005
R1312 vss.n1824 vss.n1771 4.5005
R1313 vss.n1828 vss.n1827 4.5005
R1314 vss.n1829 vss.n1770 4.5005
R1315 vss.n1833 vss.n1830 4.5005
R1316 vss.n1834 vss.n1769 4.5005
R1317 vss.n1838 vss.n1837 4.5005
R1318 vss.n1768 vss.n1767 4.5005
R1319 vss.n1837 vss.n1836 4.5005
R1320 vss.n1835 vss.n1834 4.5005
R1321 vss.n1833 vss.n1832 4.5005
R1322 vss.n1831 vss.n1770 4.5005
R1323 vss.n1827 vss.n1826 4.5005
R1324 vss.n1825 vss.n1824 4.5005
R1325 vss.n1823 vss.n1822 4.5005
R1326 vss.n1821 vss.n1772 4.5005
R1327 vss.n1817 vss.n1816 4.5005
R1328 vss.n1815 vss.n1814 4.5005
R1329 vss.n1813 vss.n1812 4.5005
R1330 vss.n1811 vss.n1774 4.5005
R1331 vss.n1806 vss.n1805 4.5005
R1332 vss.n1804 vss.n1803 4.5005
R1333 vss.n1802 vss.n1801 4.5005
R1334 vss.n1800 vss.n1776 4.5005
R1335 vss.n1796 vss.n1795 4.5005
R1336 vss.n1794 vss.n1793 4.5005
R1337 vss.n1792 vss.n1791 4.5005
R1338 vss.n1790 vss.n1778 4.5005
R1339 vss.n1786 vss.n1785 4.5005
R1340 vss.n1784 vss.n1783 4.5005
R1341 vss.n1782 vss.n1781 4.5005
R1342 vss.n1695 vss.n1691 4.5005
R1343 vss.n1699 vss.n1698 4.5005
R1344 vss.n1700 vss.n1690 4.5005
R1345 vss.n1704 vss.n1701 4.5005
R1346 vss.n1705 vss.n1689 4.5005
R1347 vss.n1709 vss.n1708 4.5005
R1348 vss.n1710 vss.n1688 4.5005
R1349 vss.n1714 vss.n1711 4.5005
R1350 vss.n1715 vss.n1687 4.5005
R1351 vss.n1719 vss.n1718 4.5005
R1352 vss.n1720 vss.n1686 4.5005
R1353 vss.n1725 vss.n1722 4.5005
R1354 vss.n1726 vss.n1685 4.5005
R1355 vss.n1730 vss.n1729 4.5005
R1356 vss.n1731 vss.n1684 4.5005
R1357 vss.n1735 vss.n1732 4.5005
R1358 vss.n1736 vss.n1683 4.5005
R1359 vss.n1740 vss.n1739 4.5005
R1360 vss.n1741 vss.n1682 4.5005
R1361 vss.n1745 vss.n1742 4.5005
R1362 vss.n1746 vss.n1681 4.5005
R1363 vss.n1750 vss.n1749 4.5005
R1364 vss.n1680 vss.n1679 4.5005
R1365 vss.n1749 vss.n1748 4.5005
R1366 vss.n1747 vss.n1746 4.5005
R1367 vss.n1745 vss.n1744 4.5005
R1368 vss.n1743 vss.n1682 4.5005
R1369 vss.n1739 vss.n1738 4.5005
R1370 vss.n1737 vss.n1736 4.5005
R1371 vss.n1735 vss.n1734 4.5005
R1372 vss.n1733 vss.n1684 4.5005
R1373 vss.n1729 vss.n1728 4.5005
R1374 vss.n1727 vss.n1726 4.5005
R1375 vss.n1725 vss.n1724 4.5005
R1376 vss.n1723 vss.n1686 4.5005
R1377 vss.n1718 vss.n1717 4.5005
R1378 vss.n1716 vss.n1715 4.5005
R1379 vss.n1714 vss.n1713 4.5005
R1380 vss.n1712 vss.n1688 4.5005
R1381 vss.n1708 vss.n1707 4.5005
R1382 vss.n1706 vss.n1705 4.5005
R1383 vss.n1704 vss.n1703 4.5005
R1384 vss.n1702 vss.n1690 4.5005
R1385 vss.n1698 vss.n1697 4.5005
R1386 vss.n1696 vss.n1695 4.5005
R1387 vss.n1694 vss.n1693 4.5005
R1388 vss.n1607 vss.n1603 4.5005
R1389 vss.n1611 vss.n1610 4.5005
R1390 vss.n1612 vss.n1602 4.5005
R1391 vss.n1616 vss.n1613 4.5005
R1392 vss.n1617 vss.n1601 4.5005
R1393 vss.n1621 vss.n1620 4.5005
R1394 vss.n1622 vss.n1600 4.5005
R1395 vss.n1626 vss.n1623 4.5005
R1396 vss.n1627 vss.n1599 4.5005
R1397 vss.n1631 vss.n1630 4.5005
R1398 vss.n1632 vss.n1598 4.5005
R1399 vss.n1637 vss.n1634 4.5005
R1400 vss.n1638 vss.n1597 4.5005
R1401 vss.n1642 vss.n1641 4.5005
R1402 vss.n1643 vss.n1596 4.5005
R1403 vss.n1647 vss.n1644 4.5005
R1404 vss.n1648 vss.n1595 4.5005
R1405 vss.n1652 vss.n1651 4.5005
R1406 vss.n1653 vss.n1594 4.5005
R1407 vss.n1657 vss.n1654 4.5005
R1408 vss.n1658 vss.n1593 4.5005
R1409 vss.n1662 vss.n1661 4.5005
R1410 vss.n1592 vss.n1591 4.5005
R1411 vss.n1661 vss.n1660 4.5005
R1412 vss.n1659 vss.n1658 4.5005
R1413 vss.n1657 vss.n1656 4.5005
R1414 vss.n1655 vss.n1594 4.5005
R1415 vss.n1651 vss.n1650 4.5005
R1416 vss.n1649 vss.n1648 4.5005
R1417 vss.n1647 vss.n1646 4.5005
R1418 vss.n1645 vss.n1596 4.5005
R1419 vss.n1641 vss.n1640 4.5005
R1420 vss.n1639 vss.n1638 4.5005
R1421 vss.n1637 vss.n1636 4.5005
R1422 vss.n1635 vss.n1598 4.5005
R1423 vss.n1630 vss.n1629 4.5005
R1424 vss.n1628 vss.n1627 4.5005
R1425 vss.n1626 vss.n1625 4.5005
R1426 vss.n1624 vss.n1600 4.5005
R1427 vss.n1620 vss.n1619 4.5005
R1428 vss.n1618 vss.n1617 4.5005
R1429 vss.n1616 vss.n1615 4.5005
R1430 vss.n1614 vss.n1602 4.5005
R1431 vss.n1610 vss.n1609 4.5005
R1432 vss.n1608 vss.n1607 4.5005
R1433 vss.n1606 vss.n1605 4.5005
R1434 vss.n1665 vss.n1578 4.5005
R1435 vss.n1665 vss.n1664 4.5005
R1436 vss.n1753 vss.n1666 4.5005
R1437 vss.n1753 vss.n1752 4.5005
R1438 vss.n1841 vss.n1754 4.5005
R1439 vss.n1841 vss.n1840 4.5005
R1440 vss.n1929 vss.n1842 4.5005
R1441 vss.n1929 vss.n1928 4.5005
R1442 vss.n2017 vss.n1930 4.5005
R1443 vss.n2017 vss.n2016 4.5005
R1444 vss.n2105 vss.n2018 4.5005
R1445 vss.n2105 vss.n2104 4.5005
R1446 vss.n2193 vss.n2106 4.5005
R1447 vss.n2193 vss.n2192 4.5005
R1448 vss.n2281 vss.n2194 4.5005
R1449 vss.n2281 vss.n2280 4.5005
R1450 vss.n2284 vss.n1577 4.5005
R1451 vss.n2290 vss.n2289 4.5005
R1452 vss.n2441 vss.n2437 4.5005
R1453 vss.n2445 vss.n2444 4.5005
R1454 vss.n2446 vss.n2436 4.5005
R1455 vss.n2450 vss.n2447 4.5005
R1456 vss.n2451 vss.n2435 4.5005
R1457 vss.n2455 vss.n2454 4.5005
R1458 vss.n2456 vss.n2434 4.5005
R1459 vss.n2460 vss.n2457 4.5005
R1460 vss.n2461 vss.n2433 4.5005
R1461 vss.n2465 vss.n2464 4.5005
R1462 vss.n2466 vss.n2432 4.5005
R1463 vss.n2471 vss.n2468 4.5005
R1464 vss.n2472 vss.n2431 4.5005
R1465 vss.n2476 vss.n2475 4.5005
R1466 vss.n2477 vss.n2430 4.5005
R1467 vss.n2481 vss.n2478 4.5005
R1468 vss.n2482 vss.n2429 4.5005
R1469 vss.n2486 vss.n2485 4.5005
R1470 vss.n2487 vss.n2428 4.5005
R1471 vss.n2491 vss.n2488 4.5005
R1472 vss.n2492 vss.n2427 4.5005
R1473 vss.n2496 vss.n2495 4.5005
R1474 vss.n2426 vss.n2425 4.5005
R1475 vss.n2495 vss.n2494 4.5005
R1476 vss.n2493 vss.n2492 4.5005
R1477 vss.n2491 vss.n2490 4.5005
R1478 vss.n2489 vss.n2428 4.5005
R1479 vss.n2485 vss.n2484 4.5005
R1480 vss.n2483 vss.n2482 4.5005
R1481 vss.n2481 vss.n2480 4.5005
R1482 vss.n2479 vss.n2430 4.5005
R1483 vss.n2475 vss.n2474 4.5005
R1484 vss.n2473 vss.n2472 4.5005
R1485 vss.n2471 vss.n2470 4.5005
R1486 vss.n2469 vss.n2432 4.5005
R1487 vss.n2464 vss.n2463 4.5005
R1488 vss.n2462 vss.n2461 4.5005
R1489 vss.n2460 vss.n2459 4.5005
R1490 vss.n2458 vss.n2434 4.5005
R1491 vss.n2454 vss.n2453 4.5005
R1492 vss.n2452 vss.n2451 4.5005
R1493 vss.n2450 vss.n2449 4.5005
R1494 vss.n2448 vss.n2436 4.5005
R1495 vss.n2444 vss.n2443 4.5005
R1496 vss.n2442 vss.n2441 4.5005
R1497 vss.n2440 vss.n2439 4.5005
R1498 vss.n2353 vss.n2349 4.5005
R1499 vss.n2357 vss.n2356 4.5005
R1500 vss.n2358 vss.n2348 4.5005
R1501 vss.n2362 vss.n2359 4.5005
R1502 vss.n2363 vss.n2347 4.5005
R1503 vss.n2367 vss.n2366 4.5005
R1504 vss.n2368 vss.n2346 4.5005
R1505 vss.n2372 vss.n2369 4.5005
R1506 vss.n2373 vss.n2345 4.5005
R1507 vss.n2377 vss.n2376 4.5005
R1508 vss.n2378 vss.n2344 4.5005
R1509 vss.n2383 vss.n2380 4.5005
R1510 vss.n2384 vss.n2343 4.5005
R1511 vss.n2388 vss.n2387 4.5005
R1512 vss.n2389 vss.n2342 4.5005
R1513 vss.n2393 vss.n2390 4.5005
R1514 vss.n2394 vss.n2341 4.5005
R1515 vss.n2398 vss.n2397 4.5005
R1516 vss.n2399 vss.n2340 4.5005
R1517 vss.n2403 vss.n2400 4.5005
R1518 vss.n2404 vss.n2339 4.5005
R1519 vss.n2408 vss.n2407 4.5005
R1520 vss.n2338 vss.n2337 4.5005
R1521 vss.n2407 vss.n2406 4.5005
R1522 vss.n2405 vss.n2404 4.5005
R1523 vss.n2403 vss.n2402 4.5005
R1524 vss.n2401 vss.n2340 4.5005
R1525 vss.n2397 vss.n2396 4.5005
R1526 vss.n2395 vss.n2394 4.5005
R1527 vss.n2393 vss.n2392 4.5005
R1528 vss.n2391 vss.n2342 4.5005
R1529 vss.n2387 vss.n2386 4.5005
R1530 vss.n2385 vss.n2384 4.5005
R1531 vss.n2383 vss.n2382 4.5005
R1532 vss.n2381 vss.n2344 4.5005
R1533 vss.n2376 vss.n2375 4.5005
R1534 vss.n2374 vss.n2373 4.5005
R1535 vss.n2372 vss.n2371 4.5005
R1536 vss.n2370 vss.n2346 4.5005
R1537 vss.n2366 vss.n2365 4.5005
R1538 vss.n2364 vss.n2363 4.5005
R1539 vss.n2362 vss.n2361 4.5005
R1540 vss.n2360 vss.n2348 4.5005
R1541 vss.n2356 vss.n2355 4.5005
R1542 vss.n2354 vss.n2353 4.5005
R1543 vss.n2352 vss.n2351 4.5005
R1544 vss.n2411 vss.n2324 4.5005
R1545 vss.n2411 vss.n2410 4.5005
R1546 vss.n2499 vss.n2412 4.5005
R1547 vss.n2499 vss.n2498 4.5005
R1548 vss.n2501 vss.n121 4.5005
R1549 vss.n2503 vss.n2502 4.5005
R1550 vss.n2799 vss.n2795 4.5005
R1551 vss.n2803 vss.n2802 4.5005
R1552 vss.n2804 vss.n2794 4.5005
R1553 vss.n2808 vss.n2805 4.5005
R1554 vss.n2809 vss.n2793 4.5005
R1555 vss.n2813 vss.n2812 4.5005
R1556 vss.n2814 vss.n2792 4.5005
R1557 vss.n2818 vss.n2815 4.5005
R1558 vss.n2819 vss.n2791 4.5005
R1559 vss.n2823 vss.n2822 4.5005
R1560 vss.n2824 vss.n2790 4.5005
R1561 vss.n2829 vss.n2826 4.5005
R1562 vss.n2830 vss.n2789 4.5005
R1563 vss.n2834 vss.n2833 4.5005
R1564 vss.n2835 vss.n2788 4.5005
R1565 vss.n2839 vss.n2836 4.5005
R1566 vss.n2840 vss.n2787 4.5005
R1567 vss.n2844 vss.n2843 4.5005
R1568 vss.n2845 vss.n2786 4.5005
R1569 vss.n2849 vss.n2846 4.5005
R1570 vss.n2850 vss.n2785 4.5005
R1571 vss.n2854 vss.n2853 4.5005
R1572 vss.n2784 vss.n2783 4.5005
R1573 vss.n2853 vss.n2852 4.5005
R1574 vss.n2851 vss.n2850 4.5005
R1575 vss.n2849 vss.n2848 4.5005
R1576 vss.n2847 vss.n2786 4.5005
R1577 vss.n2843 vss.n2842 4.5005
R1578 vss.n2841 vss.n2840 4.5005
R1579 vss.n2839 vss.n2838 4.5005
R1580 vss.n2837 vss.n2788 4.5005
R1581 vss.n2833 vss.n2832 4.5005
R1582 vss.n2831 vss.n2830 4.5005
R1583 vss.n2829 vss.n2828 4.5005
R1584 vss.n2827 vss.n2790 4.5005
R1585 vss.n2822 vss.n2821 4.5005
R1586 vss.n2820 vss.n2819 4.5005
R1587 vss.n2818 vss.n2817 4.5005
R1588 vss.n2816 vss.n2792 4.5005
R1589 vss.n2812 vss.n2811 4.5005
R1590 vss.n2810 vss.n2809 4.5005
R1591 vss.n2808 vss.n2807 4.5005
R1592 vss.n2806 vss.n2794 4.5005
R1593 vss.n2802 vss.n2801 4.5005
R1594 vss.n2800 vss.n2799 4.5005
R1595 vss.n2798 vss.n2797 4.5005
R1596 vss.n2711 vss.n2707 4.5005
R1597 vss.n2715 vss.n2714 4.5005
R1598 vss.n2716 vss.n2706 4.5005
R1599 vss.n2720 vss.n2717 4.5005
R1600 vss.n2721 vss.n2705 4.5005
R1601 vss.n2725 vss.n2724 4.5005
R1602 vss.n2726 vss.n2704 4.5005
R1603 vss.n2730 vss.n2727 4.5005
R1604 vss.n2731 vss.n2703 4.5005
R1605 vss.n2735 vss.n2734 4.5005
R1606 vss.n2736 vss.n2702 4.5005
R1607 vss.n2741 vss.n2738 4.5005
R1608 vss.n2742 vss.n2701 4.5005
R1609 vss.n2746 vss.n2745 4.5005
R1610 vss.n2747 vss.n2700 4.5005
R1611 vss.n2751 vss.n2748 4.5005
R1612 vss.n2752 vss.n2699 4.5005
R1613 vss.n2756 vss.n2755 4.5005
R1614 vss.n2757 vss.n2698 4.5005
R1615 vss.n2761 vss.n2758 4.5005
R1616 vss.n2762 vss.n2697 4.5005
R1617 vss.n2766 vss.n2765 4.5005
R1618 vss.n2696 vss.n2695 4.5005
R1619 vss.n2765 vss.n2764 4.5005
R1620 vss.n2763 vss.n2762 4.5005
R1621 vss.n2761 vss.n2760 4.5005
R1622 vss.n2759 vss.n2698 4.5005
R1623 vss.n2755 vss.n2754 4.5005
R1624 vss.n2753 vss.n2752 4.5005
R1625 vss.n2751 vss.n2750 4.5005
R1626 vss.n2749 vss.n2700 4.5005
R1627 vss.n2745 vss.n2744 4.5005
R1628 vss.n2743 vss.n2742 4.5005
R1629 vss.n2741 vss.n2740 4.5005
R1630 vss.n2739 vss.n2702 4.5005
R1631 vss.n2734 vss.n2733 4.5005
R1632 vss.n2732 vss.n2731 4.5005
R1633 vss.n2730 vss.n2729 4.5005
R1634 vss.n2728 vss.n2704 4.5005
R1635 vss.n2724 vss.n2723 4.5005
R1636 vss.n2722 vss.n2721 4.5005
R1637 vss.n2720 vss.n2719 4.5005
R1638 vss.n2718 vss.n2706 4.5005
R1639 vss.n2714 vss.n2713 4.5005
R1640 vss.n2712 vss.n2711 4.5005
R1641 vss.n2710 vss.n2709 4.5005
R1642 vss.n2623 vss.n2619 4.5005
R1643 vss.n2627 vss.n2626 4.5005
R1644 vss.n2628 vss.n2618 4.5005
R1645 vss.n2632 vss.n2629 4.5005
R1646 vss.n2633 vss.n2617 4.5005
R1647 vss.n2637 vss.n2636 4.5005
R1648 vss.n2638 vss.n2616 4.5005
R1649 vss.n2642 vss.n2639 4.5005
R1650 vss.n2643 vss.n2615 4.5005
R1651 vss.n2647 vss.n2646 4.5005
R1652 vss.n2648 vss.n2614 4.5005
R1653 vss.n2653 vss.n2650 4.5005
R1654 vss.n2654 vss.n2613 4.5005
R1655 vss.n2658 vss.n2657 4.5005
R1656 vss.n2659 vss.n2612 4.5005
R1657 vss.n2663 vss.n2660 4.5005
R1658 vss.n2664 vss.n2611 4.5005
R1659 vss.n2668 vss.n2667 4.5005
R1660 vss.n2669 vss.n2610 4.5005
R1661 vss.n2673 vss.n2670 4.5005
R1662 vss.n2674 vss.n2609 4.5005
R1663 vss.n2678 vss.n2677 4.5005
R1664 vss.n2608 vss.n2607 4.5005
R1665 vss.n2677 vss.n2676 4.5005
R1666 vss.n2675 vss.n2674 4.5005
R1667 vss.n2673 vss.n2672 4.5005
R1668 vss.n2671 vss.n2610 4.5005
R1669 vss.n2667 vss.n2666 4.5005
R1670 vss.n2665 vss.n2664 4.5005
R1671 vss.n2663 vss.n2662 4.5005
R1672 vss.n2661 vss.n2612 4.5005
R1673 vss.n2657 vss.n2656 4.5005
R1674 vss.n2655 vss.n2654 4.5005
R1675 vss.n2653 vss.n2652 4.5005
R1676 vss.n2651 vss.n2614 4.5005
R1677 vss.n2646 vss.n2645 4.5005
R1678 vss.n2644 vss.n2643 4.5005
R1679 vss.n2642 vss.n2641 4.5005
R1680 vss.n2640 vss.n2616 4.5005
R1681 vss.n2636 vss.n2635 4.5005
R1682 vss.n2634 vss.n2633 4.5005
R1683 vss.n2632 vss.n2631 4.5005
R1684 vss.n2630 vss.n2618 4.5005
R1685 vss.n2626 vss.n2625 4.5005
R1686 vss.n2624 vss.n2623 4.5005
R1687 vss.n2622 vss.n2621 4.5005
R1688 vss.n2535 vss.n2531 4.5005
R1689 vss.n2539 vss.n2538 4.5005
R1690 vss.n2540 vss.n2530 4.5005
R1691 vss.n2544 vss.n2541 4.5005
R1692 vss.n2545 vss.n2529 4.5005
R1693 vss.n2549 vss.n2548 4.5005
R1694 vss.n2550 vss.n2528 4.5005
R1695 vss.n2554 vss.n2551 4.5005
R1696 vss.n2555 vss.n2527 4.5005
R1697 vss.n2559 vss.n2558 4.5005
R1698 vss.n2560 vss.n2526 4.5005
R1699 vss.n2565 vss.n2562 4.5005
R1700 vss.n2566 vss.n2525 4.5005
R1701 vss.n2570 vss.n2569 4.5005
R1702 vss.n2571 vss.n2524 4.5005
R1703 vss.n2575 vss.n2572 4.5005
R1704 vss.n2576 vss.n2523 4.5005
R1705 vss.n2580 vss.n2579 4.5005
R1706 vss.n2581 vss.n2522 4.5005
R1707 vss.n2585 vss.n2582 4.5005
R1708 vss.n2586 vss.n2521 4.5005
R1709 vss.n2590 vss.n2589 4.5005
R1710 vss.n2520 vss.n2519 4.5005
R1711 vss.n2589 vss.n2588 4.5005
R1712 vss.n2587 vss.n2586 4.5005
R1713 vss.n2585 vss.n2584 4.5005
R1714 vss.n2583 vss.n2522 4.5005
R1715 vss.n2579 vss.n2578 4.5005
R1716 vss.n2577 vss.n2576 4.5005
R1717 vss.n2575 vss.n2574 4.5005
R1718 vss.n2573 vss.n2524 4.5005
R1719 vss.n2569 vss.n2568 4.5005
R1720 vss.n2567 vss.n2566 4.5005
R1721 vss.n2565 vss.n2564 4.5005
R1722 vss.n2563 vss.n2526 4.5005
R1723 vss.n2558 vss.n2557 4.5005
R1724 vss.n2556 vss.n2555 4.5005
R1725 vss.n2554 vss.n2553 4.5005
R1726 vss.n2552 vss.n2528 4.5005
R1727 vss.n2548 vss.n2547 4.5005
R1728 vss.n2546 vss.n2545 4.5005
R1729 vss.n2544 vss.n2543 4.5005
R1730 vss.n2542 vss.n2530 4.5005
R1731 vss.n2538 vss.n2537 4.5005
R1732 vss.n2536 vss.n2535 4.5005
R1733 vss.n2534 vss.n2533 4.5005
R1734 vss.n2593 vss.n2506 4.5005
R1735 vss.n2593 vss.n2592 4.5005
R1736 vss.n2681 vss.n2594 4.5005
R1737 vss.n2681 vss.n2680 4.5005
R1738 vss.n2769 vss.n2682 4.5005
R1739 vss.n2769 vss.n2768 4.5005
R1740 vss.n2857 vss.n2770 4.5005
R1741 vss.n2857 vss.n2856 4.5005
R1742 vss.n2861 vss.n2860 4.5005
R1743 vss.n2859 vss.n2505 4.5005
R1744 vss.n2906 vss.n2905 4.5005
R1745 vss.n2918 vss.n2917 4.5005
R1746 vss.n2919 vss.n2904 4.5005
R1747 vss.n2921 vss.n2920 4.5005
R1748 vss.n2900 vss.n2899 4.5005
R1749 vss.n2928 vss.n2927 4.5005
R1750 vss.n2929 vss.n2898 4.5005
R1751 vss.n2931 vss.n2930 4.5005
R1752 vss.n2894 vss.n2893 4.5005
R1753 vss.n2938 vss.n2937 4.5005
R1754 vss.n2939 vss.n2892 4.5005
R1755 vss.n2942 vss.n2941 4.5005
R1756 vss.n2888 vss.n2887 4.5005
R1757 vss.n2949 vss.n2948 4.5005
R1758 vss.n2950 vss.n2886 4.5005
R1759 vss.n2952 vss.n2951 4.5005
R1760 vss.n2882 vss.n2881 4.5005
R1761 vss.n2959 vss.n2958 4.5005
R1762 vss.n2960 vss.n2880 4.5005
R1763 vss.n2962 vss.n2961 4.5005
R1764 vss.n2876 vss.n2875 4.5005
R1765 vss.n2969 vss.n2968 4.5005
R1766 vss.n2874 vss.n2873 4.5005
R1767 vss.n2968 vss.n2967 4.5005
R1768 vss.n2877 vss.n2876 4.5005
R1769 vss.n2963 vss.n2962 4.5005
R1770 vss.n2880 vss.n2879 4.5005
R1771 vss.n2958 vss.n2957 4.5005
R1772 vss.n2883 vss.n2882 4.5005
R1773 vss.n2953 vss.n2952 4.5005
R1774 vss.n2886 vss.n2885 4.5005
R1775 vss.n2948 vss.n2947 4.5005
R1776 vss.n2889 vss.n2888 4.5005
R1777 vss.n2943 vss.n2942 4.5005
R1778 vss.n2892 vss.n2891 4.5005
R1779 vss.n2937 vss.n2936 4.5005
R1780 vss.n2895 vss.n2894 4.5005
R1781 vss.n2932 vss.n2931 4.5005
R1782 vss.n2898 vss.n2897 4.5005
R1783 vss.n2927 vss.n2926 4.5005
R1784 vss.n2901 vss.n2900 4.5005
R1785 vss.n2922 vss.n2921 4.5005
R1786 vss.n2904 vss.n2903 4.5005
R1787 vss.n2917 vss.n2916 4.5005
R1788 vss.n2907 vss.n2906 4.5005
R1789 vss.n2912 vss.n2911 4.5005
R1790 vss.n2873 vss.n2872 4.5005
R1791 vss.n2967 vss.n2966 4.5005
R1792 vss.n2965 vss.n2877 4.5005
R1793 vss.n2964 vss.n2963 4.5005
R1794 vss.n2879 vss.n2878 4.5005
R1795 vss.n2957 vss.n2956 4.5005
R1796 vss.n2955 vss.n2883 4.5005
R1797 vss.n2954 vss.n2953 4.5005
R1798 vss.n2885 vss.n2884 4.5005
R1799 vss.n2947 vss.n2946 4.5005
R1800 vss.n2945 vss.n2889 4.5005
R1801 vss.n2944 vss.n2943 4.5005
R1802 vss.n2891 vss.n2890 4.5005
R1803 vss.n2936 vss.n2935 4.5005
R1804 vss.n2934 vss.n2895 4.5005
R1805 vss.n2933 vss.n2932 4.5005
R1806 vss.n2897 vss.n2896 4.5005
R1807 vss.n2926 vss.n2925 4.5005
R1808 vss.n2924 vss.n2901 4.5005
R1809 vss.n2923 vss.n2922 4.5005
R1810 vss.n2903 vss.n2902 4.5005
R1811 vss.n2916 vss.n2915 4.5005
R1812 vss.n2914 vss.n2907 4.5005
R1813 vss.n2913 vss.n2912 4.5005
R1814 vss.n2909 vss.n2908 4.5005
R1815 vss.n2972 vss.n2971 4.5005
R1816 vss.n2975 vss.n2974 4.5005
R1817 vss.n2973 vss.n2871 4.5005
R1818 vss.n96 vss.n92 4.5005
R1819 vss.n100 vss.n97 4.5005
R1820 vss.n101 vss.n91 4.5005
R1821 vss.n105 vss.n104 4.5005
R1822 vss.n107 vss.n90 4.5005
R1823 vss.n111 vss.n108 4.5005
R1824 vss.n112 vss.n89 4.5005
R1825 vss.n116 vss.n115 4.5005
R1826 vss.n88 vss.n87 4.5005
R1827 vss.n115 vss.n114 4.5005
R1828 vss.n113 vss.n112 4.5005
R1829 vss.n111 vss.n110 4.5005
R1830 vss.n109 vss.n90 4.5005
R1831 vss.n104 vss.n103 4.5005
R1832 vss.n102 vss.n101 4.5005
R1833 vss.n100 vss.n99 4.5005
R1834 vss.n98 vss.n92 4.5005
R1835 vss.n94 vss.n93 4.5005
R1836 vss.n119 vss.n81 4.5005
R1837 vss.n119 vss.n118 4.5005
R1838 vss.n2866 vss.n80 4.5005
R1839 vss.n2868 vss.n2867 4.5005
R1840 vss.n72 vss.n71 4.5005
R1841 vss.n76 vss.n75 4.5005
R1842 vss.n77 vss.n76 4.5005
R1843 vss.n2980 vss.n69 4.5005
R1844 vss.n3006 vss.n3005 4.5005
R1845 vss.n132 vss.n131 4.5005
R1846 vss.n136 vss.n135 4.5005
R1847 vss.n126 vss.n125 4.5005
R1848 vss.n135 vss.n134 4.5005
R1849 vss.n133 vss.n132 4.5005
R1850 vss.n129 vss.n128 4.5005
R1851 vss.n139 vss.n122 4.5005
R1852 vss.n139 vss.n138 4.5005
R1853 vss.n68 vss.n67 4.5005
R1854 vss.n3010 vss.n3009 4.5005
R1855 vss.n59 vss.n51 4.5005
R1856 vss.n3015 vss.n51 4.5005
R1857 vss.n3017 vss.n51 4.5005
R1858 vss.n63 vss.n53 4.5005
R1859 vss.n3015 vss.n53 4.5005
R1860 vss.n3017 vss.n53 4.5005
R1861 vss.n61 vss.n50 4.5005
R1862 vss.n59 vss.n50 4.5005
R1863 vss.n63 vss.n50 4.5005
R1864 vss.n3015 vss.n50 4.5005
R1865 vss.n3017 vss.n50 4.5005
R1866 vss.n61 vss.n54 4.5005
R1867 vss.n59 vss.n54 4.5005
R1868 vss.n63 vss.n54 4.5005
R1869 vss.n3015 vss.n54 4.5005
R1870 vss.n3017 vss.n54 4.5005
R1871 vss.n61 vss.n49 4.5005
R1872 vss.n59 vss.n49 4.5005
R1873 vss.n63 vss.n49 4.5005
R1874 vss.n3015 vss.n49 4.5005
R1875 vss.n3017 vss.n49 4.5005
R1876 vss.n3016 vss.n61 4.5005
R1877 vss.n3016 vss.n59 4.5005
R1878 vss.n3016 vss.n63 4.5005
R1879 vss.n3016 vss.n58 4.5005
R1880 vss.n3016 vss.n3015 4.5005
R1881 vss.n3017 vss.n3016 4.5005
R1882 vss.n3004 vss.n2984 4.5005
R1883 vss.n3004 vss.n3003 4.5005
R1884 vss.n2998 vss.n2987 4.5005
R1885 vss.n2987 vss.n2984 4.5005
R1886 vss.n3003 vss.n2987 4.5005
R1887 vss.n2998 vss.n2990 4.5005
R1888 vss.n2997 vss.n2990 4.5005
R1889 vss.n3000 vss.n2990 4.5005
R1890 vss.n2990 vss.n2984 4.5005
R1891 vss.n3003 vss.n2990 4.5005
R1892 vss.n2998 vss.n2986 4.5005
R1893 vss.n2997 vss.n2986 4.5005
R1894 vss.n3000 vss.n2986 4.5005
R1895 vss.n2986 vss.n2984 4.5005
R1896 vss.n3003 vss.n2986 4.5005
R1897 vss.n2998 vss.n2992 4.5005
R1898 vss.n2997 vss.n2992 4.5005
R1899 vss.n3000 vss.n2992 4.5005
R1900 vss.n2992 vss.n2984 4.5005
R1901 vss.n3003 vss.n2992 4.5005
R1902 vss.n2998 vss.n2985 4.5005
R1903 vss.n2997 vss.n2985 4.5005
R1904 vss.n3000 vss.n2985 4.5005
R1905 vss.n2985 vss.n2984 4.5005
R1906 vss.n3003 vss.n2985 4.5005
R1907 vss.n3002 vss.n2998 4.5005
R1908 vss.n3002 vss.n2997 4.5005
R1909 vss.n3002 vss.n3000 4.5005
R1910 vss.n3003 vss.n3002 4.5005
R1911 vss.n3026 vss.n42 4.5005
R1912 vss.n3029 vss.n42 4.5005
R1913 vss.n3019 vss.n39 4.5005
R1914 vss.n3026 vss.n39 4.5005
R1915 vss.n3029 vss.n39 4.5005
R1916 vss.n3019 vss.n44 4.5005
R1917 vss.n48 vss.n44 4.5005
R1918 vss.n3021 vss.n44 4.5005
R1919 vss.n3026 vss.n44 4.5005
R1920 vss.n3029 vss.n44 4.5005
R1921 vss.n3019 vss.n38 4.5005
R1922 vss.n48 vss.n38 4.5005
R1923 vss.n3021 vss.n38 4.5005
R1924 vss.n3026 vss.n38 4.5005
R1925 vss.n3029 vss.n38 4.5005
R1926 vss.n3019 vss.n46 4.5005
R1927 vss.n48 vss.n46 4.5005
R1928 vss.n3021 vss.n46 4.5005
R1929 vss.n3026 vss.n46 4.5005
R1930 vss.n3029 vss.n46 4.5005
R1931 vss.n3019 vss.n37 4.5005
R1932 vss.n48 vss.n37 4.5005
R1933 vss.n3021 vss.n37 4.5005
R1934 vss.n3026 vss.n37 4.5005
R1935 vss.n3029 vss.n37 4.5005
R1936 vss.n3028 vss.n3019 4.5005
R1937 vss.n3028 vss.n48 4.5005
R1938 vss.n3028 vss.n3021 4.5005
R1939 vss.n3029 vss.n3028 4.5005
R1940 vss.n3038 vss.n30 4.5005
R1941 vss.n3041 vss.n30 4.5005
R1942 vss.n3031 vss.n27 4.5005
R1943 vss.n3038 vss.n27 4.5005
R1944 vss.n3041 vss.n27 4.5005
R1945 vss.n3031 vss.n32 4.5005
R1946 vss.n36 vss.n32 4.5005
R1947 vss.n3033 vss.n32 4.5005
R1948 vss.n3038 vss.n32 4.5005
R1949 vss.n3041 vss.n32 4.5005
R1950 vss.n3031 vss.n26 4.5005
R1951 vss.n36 vss.n26 4.5005
R1952 vss.n3033 vss.n26 4.5005
R1953 vss.n3038 vss.n26 4.5005
R1954 vss.n3041 vss.n26 4.5005
R1955 vss.n3031 vss.n34 4.5005
R1956 vss.n36 vss.n34 4.5005
R1957 vss.n3033 vss.n34 4.5005
R1958 vss.n3038 vss.n34 4.5005
R1959 vss.n3041 vss.n34 4.5005
R1960 vss.n3031 vss.n25 4.5005
R1961 vss.n36 vss.n25 4.5005
R1962 vss.n3033 vss.n25 4.5005
R1963 vss.n3038 vss.n25 4.5005
R1964 vss.n3041 vss.n25 4.5005
R1965 vss.n3040 vss.n3031 4.5005
R1966 vss.n3040 vss.n36 4.5005
R1967 vss.n3040 vss.n3033 4.5005
R1968 vss.n3041 vss.n3040 4.5005
R1969 vss.n2316 vss.n1559 4.5005
R1970 vss.n2316 vss.n2315 4.5005
R1971 vss.n2310 vss.n1562 4.5005
R1972 vss.n1562 vss.n1559 4.5005
R1973 vss.n2315 vss.n1562 4.5005
R1974 vss.n2310 vss.n1565 4.5005
R1975 vss.n1572 vss.n1565 4.5005
R1976 vss.n2312 vss.n1565 4.5005
R1977 vss.n1565 vss.n1559 4.5005
R1978 vss.n2315 vss.n1565 4.5005
R1979 vss.n2310 vss.n1561 4.5005
R1980 vss.n1572 vss.n1561 4.5005
R1981 vss.n2312 vss.n1561 4.5005
R1982 vss.n1561 vss.n1559 4.5005
R1983 vss.n2315 vss.n1561 4.5005
R1984 vss.n2310 vss.n1567 4.5005
R1985 vss.n1572 vss.n1567 4.5005
R1986 vss.n2312 vss.n1567 4.5005
R1987 vss.n1567 vss.n1559 4.5005
R1988 vss.n2315 vss.n1567 4.5005
R1989 vss.n2310 vss.n1560 4.5005
R1990 vss.n1572 vss.n1560 4.5005
R1991 vss.n2312 vss.n1560 4.5005
R1992 vss.n1560 vss.n1559 4.5005
R1993 vss.n2315 vss.n1560 4.5005
R1994 vss.n2314 vss.n2310 4.5005
R1995 vss.n2314 vss.n1572 4.5005
R1996 vss.n2314 vss.n2312 4.5005
R1997 vss.n2315 vss.n2314 4.5005
R1998 vss.n3062 vss.n6 4.5005
R1999 vss.n3065 vss.n6 4.5005
R2000 vss.n3055 vss.n3 4.5005
R2001 vss.n3062 vss.n3 4.5005
R2002 vss.n3065 vss.n3 4.5005
R2003 vss.n3055 vss.n8 4.5005
R2004 vss.n12 vss.n8 4.5005
R2005 vss.n3057 vss.n8 4.5005
R2006 vss.n3062 vss.n8 4.5005
R2007 vss.n3065 vss.n8 4.5005
R2008 vss.n3055 vss.n2 4.5005
R2009 vss.n12 vss.n2 4.5005
R2010 vss.n3057 vss.n2 4.5005
R2011 vss.n3062 vss.n2 4.5005
R2012 vss.n3065 vss.n2 4.5005
R2013 vss.n3055 vss.n10 4.5005
R2014 vss.n12 vss.n10 4.5005
R2015 vss.n3057 vss.n10 4.5005
R2016 vss.n3062 vss.n10 4.5005
R2017 vss.n3065 vss.n10 4.5005
R2018 vss.n3055 vss.n1 4.5005
R2019 vss.n12 vss.n1 4.5005
R2020 vss.n3057 vss.n1 4.5005
R2021 vss.n3062 vss.n1 4.5005
R2022 vss.n3065 vss.n1 4.5005
R2023 vss.n3064 vss.n3055 4.5005
R2024 vss.n3064 vss.n12 4.5005
R2025 vss.n3064 vss.n3057 4.5005
R2026 vss.n3065 vss.n3064 4.5005
R2027 vss.n3050 vss.n18 4.5005
R2028 vss.n3053 vss.n18 4.5005
R2029 vss.n3043 vss.n15 4.5005
R2030 vss.n3050 vss.n15 4.5005
R2031 vss.n3053 vss.n15 4.5005
R2032 vss.n3043 vss.n20 4.5005
R2033 vss.n24 vss.n20 4.5005
R2034 vss.n3045 vss.n20 4.5005
R2035 vss.n3050 vss.n20 4.5005
R2036 vss.n3053 vss.n20 4.5005
R2037 vss.n3043 vss.n14 4.5005
R2038 vss.n24 vss.n14 4.5005
R2039 vss.n3045 vss.n14 4.5005
R2040 vss.n3050 vss.n14 4.5005
R2041 vss.n3053 vss.n14 4.5005
R2042 vss.n3043 vss.n22 4.5005
R2043 vss.n24 vss.n22 4.5005
R2044 vss.n3045 vss.n22 4.5005
R2045 vss.n3050 vss.n22 4.5005
R2046 vss.n3053 vss.n22 4.5005
R2047 vss.n3043 vss.n13 4.5005
R2048 vss.n24 vss.n13 4.5005
R2049 vss.n3045 vss.n13 4.5005
R2050 vss.n3050 vss.n13 4.5005
R2051 vss.n3053 vss.n13 4.5005
R2052 vss.n3052 vss.n3043 4.5005
R2053 vss.n3052 vss.n24 4.5005
R2054 vss.n3052 vss.n3045 4.5005
R2055 vss.n3053 vss.n3052 4.5005
R2056 vss.n2306 vss.n2292 4.5005
R2057 vss.n2309 vss.n2292 4.5005
R2058 vss.n1575 vss.n0 4.5005
R2059 vss.n2306 vss.n1575 4.5005
R2060 vss.n2309 vss.n1575 4.5005
R2061 vss.n2294 vss.n0 4.5005
R2062 vss.n2299 vss.n2294 4.5005
R2063 vss.n2301 vss.n2294 4.5005
R2064 vss.n2306 vss.n2294 4.5005
R2065 vss.n2309 vss.n2294 4.5005
R2066 vss.n1574 vss.n0 4.5005
R2067 vss.n2299 vss.n1574 4.5005
R2068 vss.n2301 vss.n1574 4.5005
R2069 vss.n2306 vss.n1574 4.5005
R2070 vss.n2309 vss.n1574 4.5005
R2071 vss.n2296 vss.n0 4.5005
R2072 vss.n2299 vss.n2296 4.5005
R2073 vss.n2301 vss.n2296 4.5005
R2074 vss.n2306 vss.n2296 4.5005
R2075 vss.n2309 vss.n2296 4.5005
R2076 vss.n1573 vss.n0 4.5005
R2077 vss.n2299 vss.n1573 4.5005
R2078 vss.n2301 vss.n1573 4.5005
R2079 vss.n2306 vss.n1573 4.5005
R2080 vss.n2309 vss.n1573 4.5005
R2081 vss.n2308 vss.n0 4.5005
R2082 vss.n2308 vss.n2299 4.5005
R2083 vss.n2308 vss.n2301 4.5005
R2084 vss.n2309 vss.n2308 4.5005
R2085 vss.n2286 vss.t55 4.29802
R2086 vss.n74 vss.t3 4.253
R2087 vss.n2863 vss.n120 3.76083
R2088 vss.n2862 vss.t45 3.6713
R2089 vss.t0 vss.t2 2.86551
R2090 vss.n2504 vss.t50 2.50739
R2091 vss.t51 vss.t52 2.50739
R2092 vss.n2319 vss.n145 2.4305
R2093 vss.n2284 vss.n2283 2.4305
R2094 vss.n2323 vss.n121 2.4305
R2095 vss.n2861 vss.n143 2.4305
R2096 vss.n2975 vss.n79 2.4305
R2097 vss.t46 vss.n142 2.37309
R2098 vss.n2869 vss.t57 2.37309
R2099 vss.n1493 vss.n1492 2.311
R2100 vss.n1552 vss.n1551 2.311
R2101 vss.n1405 vss.n1404 2.311
R2102 vss.n1464 vss.n1463 2.311
R2103 vss.n1317 vss.n1316 2.311
R2104 vss.n1376 vss.n1375 2.311
R2105 vss.n1229 vss.n1228 2.311
R2106 vss.n1288 vss.n1287 2.311
R2107 vss.n1141 vss.n1140 2.311
R2108 vss.n1200 vss.n1199 2.311
R2109 vss.n1053 vss.n1052 2.311
R2110 vss.n1112 vss.n1111 2.311
R2111 vss.n965 vss.n964 2.311
R2112 vss.n1024 vss.n1023 2.311
R2113 vss.n877 vss.n876 2.311
R2114 vss.n936 vss.n935 2.311
R2115 vss.n789 vss.n788 2.311
R2116 vss.n848 vss.n847 2.311
R2117 vss.n701 vss.n700 2.311
R2118 vss.n760 vss.n759 2.311
R2119 vss.n613 vss.n612 2.311
R2120 vss.n672 vss.n671 2.311
R2121 vss.n525 vss.n524 2.311
R2122 vss.n584 vss.n583 2.311
R2123 vss.n437 vss.n436 2.311
R2124 vss.n496 vss.n495 2.311
R2125 vss.n349 vss.n348 2.311
R2126 vss.n408 vss.n407 2.311
R2127 vss.n261 vss.n260 2.311
R2128 vss.n320 vss.n319 2.311
R2129 vss.n173 vss.n172 2.311
R2130 vss.n232 vss.n231 2.311
R2131 vss.n2220 vss.n2219 2.311
R2132 vss.n2279 vss.n2278 2.311
R2133 vss.n2132 vss.n2131 2.311
R2134 vss.n2191 vss.n2190 2.311
R2135 vss.n2044 vss.n2043 2.311
R2136 vss.n2103 vss.n2102 2.311
R2137 vss.n1956 vss.n1955 2.311
R2138 vss.n2015 vss.n2014 2.311
R2139 vss.n1868 vss.n1867 2.311
R2140 vss.n1927 vss.n1926 2.311
R2141 vss.n1780 vss.n1779 2.311
R2142 vss.n1839 vss.n1838 2.311
R2143 vss.n1692 vss.n1691 2.311
R2144 vss.n1751 vss.n1750 2.311
R2145 vss.n1604 vss.n1603 2.311
R2146 vss.n1663 vss.n1662 2.311
R2147 vss.n2438 vss.n2437 2.311
R2148 vss.n2497 vss.n2496 2.311
R2149 vss.n2350 vss.n2349 2.311
R2150 vss.n2409 vss.n2408 2.311
R2151 vss.n2796 vss.n2795 2.311
R2152 vss.n2855 vss.n2854 2.311
R2153 vss.n2708 vss.n2707 2.311
R2154 vss.n2767 vss.n2766 2.311
R2155 vss.n2620 vss.n2619 2.311
R2156 vss.n2679 vss.n2678 2.311
R2157 vss.n2532 vss.n2531 2.311
R2158 vss.n2591 vss.n2590 2.311
R2159 vss.n2910 vss.n2905 2.311
R2160 vss.n2970 vss.n2969 2.311
R2161 vss.n96 vss.n95 2.311
R2162 vss.n117 vss.n116 2.311
R2163 vss.n131 vss.n130 2.311
R2164 vss.n137 vss.n136 2.311
R2165 vss.n2319 vss.n146 2.2811
R2166 vss.n74 vss.n73 2.251
R2167 vss.n3013 vss.n3011 2.25059
R2168 vss.n3014 vss.n3013 2.25059
R2169 vss.n3013 vss.n52 2.25059
R2170 vss.n62 vss.n51 2.25059
R2171 vss.n60 vss.n53 2.25059
R2172 vss.n3004 vss.n2983 2.25059
R2173 vss.n3004 vss.n2982 2.25059
R2174 vss.n2999 vss.n2987 2.25059
R2175 vss.n3002 vss.n3001 2.25059
R2176 vss.n3018 vss.n42 2.25059
R2177 vss.n3022 vss.n42 2.25059
R2178 vss.n3020 vss.n39 2.25059
R2179 vss.n3028 vss.n3027 2.25059
R2180 vss.n3030 vss.n30 2.25059
R2181 vss.n3034 vss.n30 2.25059
R2182 vss.n3032 vss.n27 2.25059
R2183 vss.n3040 vss.n3039 2.25059
R2184 vss.n2316 vss.n1558 2.25059
R2185 vss.n2316 vss.n1557 2.25059
R2186 vss.n2311 vss.n1562 2.25059
R2187 vss.n2314 vss.n2313 2.25059
R2188 vss.n3054 vss.n6 2.25059
R2189 vss.n3058 vss.n6 2.25059
R2190 vss.n3056 vss.n3 2.25059
R2191 vss.n3064 vss.n3063 2.25059
R2192 vss.n3042 vss.n18 2.25059
R2193 vss.n3046 vss.n18 2.25059
R2194 vss.n3044 vss.n15 2.25059
R2195 vss.n3052 vss.n3051 2.25059
R2196 vss.n2298 vss.n2292 2.25059
R2197 vss.n2302 vss.n2292 2.25059
R2198 vss.n2300 vss.n1575 2.25059
R2199 vss.n2308 vss.n2307 2.25059
R2200 vss.n3012 vss.n61 2.24954
R2201 vss.n66 vss.n64 2.24954
R2202 vss.n58 vss.n57 2.24954
R2203 vss.n66 vss.n65 2.24954
R2204 vss.n58 vss.n56 2.24954
R2205 vss.n66 vss.n55 2.24954
R2206 vss.n2988 vss.n2981 2.24954
R2207 vss.n2995 vss.n2993 2.24954
R2208 vss.n2989 vss.n2988 2.24954
R2209 vss.n2995 vss.n2994 2.24954
R2210 vss.n2991 vss.n2988 2.24954
R2211 vss.n2996 vss.n2995 2.24954
R2212 vss.n41 vss.n40 2.24954
R2213 vss.n3025 vss.n3023 2.24954
R2214 vss.n43 vss.n40 2.24954
R2215 vss.n3025 vss.n3024 2.24954
R2216 vss.n45 vss.n40 2.24954
R2217 vss.n3025 vss.n47 2.24954
R2218 vss.n29 vss.n28 2.24954
R2219 vss.n3037 vss.n3035 2.24954
R2220 vss.n31 vss.n28 2.24954
R2221 vss.n3037 vss.n3036 2.24954
R2222 vss.n33 vss.n28 2.24954
R2223 vss.n3037 vss.n35 2.24954
R2224 vss.n1563 vss.n1556 2.24954
R2225 vss.n1570 vss.n1568 2.24954
R2226 vss.n1564 vss.n1563 2.24954
R2227 vss.n1570 vss.n1569 2.24954
R2228 vss.n1566 vss.n1563 2.24954
R2229 vss.n1571 vss.n1570 2.24954
R2230 vss.n5 vss.n4 2.24954
R2231 vss.n3061 vss.n3059 2.24954
R2232 vss.n7 vss.n4 2.24954
R2233 vss.n3061 vss.n3060 2.24954
R2234 vss.n9 vss.n4 2.24954
R2235 vss.n3061 vss.n11 2.24954
R2236 vss.n17 vss.n16 2.24954
R2237 vss.n3049 vss.n3047 2.24954
R2238 vss.n19 vss.n16 2.24954
R2239 vss.n3049 vss.n3048 2.24954
R2240 vss.n21 vss.n16 2.24954
R2241 vss.n3049 vss.n23 2.24954
R2242 vss.n2291 vss.n1576 2.24954
R2243 vss.n2305 vss.n2303 2.24954
R2244 vss.n2293 vss.n1576 2.24954
R2245 vss.n2305 vss.n2304 2.24954
R2246 vss.n2295 vss.n1576 2.24954
R2247 vss.n2305 vss.n2297 2.24954
R2248 vss.n234 vss.n159 2.2361
R2249 vss.n234 vss.n158 2.2361
R2250 vss.n234 vss.n157 2.2361
R2251 vss.n234 vss.n156 2.2361
R2252 vss.n234 vss.n155 2.2361
R2253 vss.n234 vss.n154 2.2361
R2254 vss.n234 vss.n153 2.2361
R2255 vss.n234 vss.n152 2.2361
R2256 vss.n234 vss.n151 2.2361
R2257 vss.n234 vss.n150 2.2361
R2258 vss.n234 vss.n149 2.2361
R2259 vss.n234 vss.n148 2.2361
R2260 vss.n322 vss.n247 2.2361
R2261 vss.n322 vss.n246 2.2361
R2262 vss.n322 vss.n245 2.2361
R2263 vss.n322 vss.n244 2.2361
R2264 vss.n322 vss.n243 2.2361
R2265 vss.n322 vss.n242 2.2361
R2266 vss.n322 vss.n241 2.2361
R2267 vss.n322 vss.n240 2.2361
R2268 vss.n322 vss.n239 2.2361
R2269 vss.n322 vss.n238 2.2361
R2270 vss.n322 vss.n237 2.2361
R2271 vss.n322 vss.n236 2.2361
R2272 vss.n410 vss.n335 2.2361
R2273 vss.n410 vss.n334 2.2361
R2274 vss.n410 vss.n333 2.2361
R2275 vss.n410 vss.n332 2.2361
R2276 vss.n410 vss.n331 2.2361
R2277 vss.n410 vss.n330 2.2361
R2278 vss.n410 vss.n329 2.2361
R2279 vss.n410 vss.n328 2.2361
R2280 vss.n410 vss.n327 2.2361
R2281 vss.n410 vss.n326 2.2361
R2282 vss.n410 vss.n325 2.2361
R2283 vss.n410 vss.n324 2.2361
R2284 vss.n498 vss.n423 2.2361
R2285 vss.n498 vss.n422 2.2361
R2286 vss.n498 vss.n421 2.2361
R2287 vss.n498 vss.n420 2.2361
R2288 vss.n498 vss.n419 2.2361
R2289 vss.n498 vss.n418 2.2361
R2290 vss.n498 vss.n417 2.2361
R2291 vss.n498 vss.n416 2.2361
R2292 vss.n498 vss.n415 2.2361
R2293 vss.n498 vss.n414 2.2361
R2294 vss.n498 vss.n413 2.2361
R2295 vss.n498 vss.n412 2.2361
R2296 vss.n586 vss.n511 2.2361
R2297 vss.n586 vss.n510 2.2361
R2298 vss.n586 vss.n509 2.2361
R2299 vss.n586 vss.n508 2.2361
R2300 vss.n586 vss.n507 2.2361
R2301 vss.n586 vss.n506 2.2361
R2302 vss.n586 vss.n505 2.2361
R2303 vss.n586 vss.n504 2.2361
R2304 vss.n586 vss.n503 2.2361
R2305 vss.n586 vss.n502 2.2361
R2306 vss.n586 vss.n501 2.2361
R2307 vss.n586 vss.n500 2.2361
R2308 vss.n674 vss.n599 2.2361
R2309 vss.n674 vss.n598 2.2361
R2310 vss.n674 vss.n597 2.2361
R2311 vss.n674 vss.n596 2.2361
R2312 vss.n674 vss.n595 2.2361
R2313 vss.n674 vss.n594 2.2361
R2314 vss.n674 vss.n593 2.2361
R2315 vss.n674 vss.n592 2.2361
R2316 vss.n674 vss.n591 2.2361
R2317 vss.n674 vss.n590 2.2361
R2318 vss.n674 vss.n589 2.2361
R2319 vss.n674 vss.n588 2.2361
R2320 vss.n762 vss.n687 2.2361
R2321 vss.n762 vss.n686 2.2361
R2322 vss.n762 vss.n685 2.2361
R2323 vss.n762 vss.n684 2.2361
R2324 vss.n762 vss.n683 2.2361
R2325 vss.n762 vss.n682 2.2361
R2326 vss.n762 vss.n681 2.2361
R2327 vss.n762 vss.n680 2.2361
R2328 vss.n762 vss.n679 2.2361
R2329 vss.n762 vss.n678 2.2361
R2330 vss.n762 vss.n677 2.2361
R2331 vss.n762 vss.n676 2.2361
R2332 vss.n850 vss.n775 2.2361
R2333 vss.n850 vss.n774 2.2361
R2334 vss.n850 vss.n773 2.2361
R2335 vss.n850 vss.n772 2.2361
R2336 vss.n850 vss.n771 2.2361
R2337 vss.n850 vss.n770 2.2361
R2338 vss.n850 vss.n769 2.2361
R2339 vss.n850 vss.n768 2.2361
R2340 vss.n850 vss.n767 2.2361
R2341 vss.n850 vss.n766 2.2361
R2342 vss.n850 vss.n765 2.2361
R2343 vss.n850 vss.n764 2.2361
R2344 vss.n938 vss.n863 2.2361
R2345 vss.n938 vss.n862 2.2361
R2346 vss.n938 vss.n861 2.2361
R2347 vss.n938 vss.n860 2.2361
R2348 vss.n938 vss.n859 2.2361
R2349 vss.n938 vss.n858 2.2361
R2350 vss.n938 vss.n857 2.2361
R2351 vss.n938 vss.n856 2.2361
R2352 vss.n938 vss.n855 2.2361
R2353 vss.n938 vss.n854 2.2361
R2354 vss.n938 vss.n853 2.2361
R2355 vss.n938 vss.n852 2.2361
R2356 vss.n1026 vss.n951 2.2361
R2357 vss.n1026 vss.n950 2.2361
R2358 vss.n1026 vss.n949 2.2361
R2359 vss.n1026 vss.n948 2.2361
R2360 vss.n1026 vss.n947 2.2361
R2361 vss.n1026 vss.n946 2.2361
R2362 vss.n1026 vss.n945 2.2361
R2363 vss.n1026 vss.n944 2.2361
R2364 vss.n1026 vss.n943 2.2361
R2365 vss.n1026 vss.n942 2.2361
R2366 vss.n1026 vss.n941 2.2361
R2367 vss.n1026 vss.n940 2.2361
R2368 vss.n1114 vss.n1039 2.2361
R2369 vss.n1114 vss.n1038 2.2361
R2370 vss.n1114 vss.n1037 2.2361
R2371 vss.n1114 vss.n1036 2.2361
R2372 vss.n1114 vss.n1035 2.2361
R2373 vss.n1114 vss.n1034 2.2361
R2374 vss.n1114 vss.n1033 2.2361
R2375 vss.n1114 vss.n1032 2.2361
R2376 vss.n1114 vss.n1031 2.2361
R2377 vss.n1114 vss.n1030 2.2361
R2378 vss.n1114 vss.n1029 2.2361
R2379 vss.n1114 vss.n1028 2.2361
R2380 vss.n1202 vss.n1127 2.2361
R2381 vss.n1202 vss.n1126 2.2361
R2382 vss.n1202 vss.n1125 2.2361
R2383 vss.n1202 vss.n1124 2.2361
R2384 vss.n1202 vss.n1123 2.2361
R2385 vss.n1202 vss.n1122 2.2361
R2386 vss.n1202 vss.n1121 2.2361
R2387 vss.n1202 vss.n1120 2.2361
R2388 vss.n1202 vss.n1119 2.2361
R2389 vss.n1202 vss.n1118 2.2361
R2390 vss.n1202 vss.n1117 2.2361
R2391 vss.n1202 vss.n1116 2.2361
R2392 vss.n1290 vss.n1215 2.2361
R2393 vss.n1290 vss.n1214 2.2361
R2394 vss.n1290 vss.n1213 2.2361
R2395 vss.n1290 vss.n1212 2.2361
R2396 vss.n1290 vss.n1211 2.2361
R2397 vss.n1290 vss.n1210 2.2361
R2398 vss.n1290 vss.n1209 2.2361
R2399 vss.n1290 vss.n1208 2.2361
R2400 vss.n1290 vss.n1207 2.2361
R2401 vss.n1290 vss.n1206 2.2361
R2402 vss.n1290 vss.n1205 2.2361
R2403 vss.n1290 vss.n1204 2.2361
R2404 vss.n1378 vss.n1303 2.2361
R2405 vss.n1378 vss.n1302 2.2361
R2406 vss.n1378 vss.n1301 2.2361
R2407 vss.n1378 vss.n1300 2.2361
R2408 vss.n1378 vss.n1299 2.2361
R2409 vss.n1378 vss.n1298 2.2361
R2410 vss.n1378 vss.n1297 2.2361
R2411 vss.n1378 vss.n1296 2.2361
R2412 vss.n1378 vss.n1295 2.2361
R2413 vss.n1378 vss.n1294 2.2361
R2414 vss.n1378 vss.n1293 2.2361
R2415 vss.n1378 vss.n1292 2.2361
R2416 vss.n1466 vss.n1391 2.2361
R2417 vss.n1466 vss.n1390 2.2361
R2418 vss.n1466 vss.n1389 2.2361
R2419 vss.n1466 vss.n1388 2.2361
R2420 vss.n1466 vss.n1387 2.2361
R2421 vss.n1466 vss.n1386 2.2361
R2422 vss.n1466 vss.n1385 2.2361
R2423 vss.n1466 vss.n1384 2.2361
R2424 vss.n1466 vss.n1383 2.2361
R2425 vss.n1466 vss.n1382 2.2361
R2426 vss.n1466 vss.n1381 2.2361
R2427 vss.n1466 vss.n1380 2.2361
R2428 vss.n1554 vss.n1479 2.2361
R2429 vss.n1554 vss.n1478 2.2361
R2430 vss.n1554 vss.n1477 2.2361
R2431 vss.n1554 vss.n1476 2.2361
R2432 vss.n1554 vss.n1475 2.2361
R2433 vss.n1554 vss.n1474 2.2361
R2434 vss.n1554 vss.n1473 2.2361
R2435 vss.n1554 vss.n1472 2.2361
R2436 vss.n1554 vss.n1471 2.2361
R2437 vss.n1554 vss.n1470 2.2361
R2438 vss.n1554 vss.n1469 2.2361
R2439 vss.n1554 vss.n1468 2.2361
R2440 vss.n1665 vss.n1590 2.2361
R2441 vss.n1665 vss.n1589 2.2361
R2442 vss.n1665 vss.n1588 2.2361
R2443 vss.n1665 vss.n1587 2.2361
R2444 vss.n1665 vss.n1586 2.2361
R2445 vss.n1665 vss.n1585 2.2361
R2446 vss.n1665 vss.n1584 2.2361
R2447 vss.n1665 vss.n1583 2.2361
R2448 vss.n1665 vss.n1582 2.2361
R2449 vss.n1665 vss.n1581 2.2361
R2450 vss.n1665 vss.n1580 2.2361
R2451 vss.n1665 vss.n1579 2.2361
R2452 vss.n1753 vss.n1678 2.2361
R2453 vss.n1753 vss.n1677 2.2361
R2454 vss.n1753 vss.n1676 2.2361
R2455 vss.n1753 vss.n1675 2.2361
R2456 vss.n1753 vss.n1674 2.2361
R2457 vss.n1753 vss.n1673 2.2361
R2458 vss.n1753 vss.n1672 2.2361
R2459 vss.n1753 vss.n1671 2.2361
R2460 vss.n1753 vss.n1670 2.2361
R2461 vss.n1753 vss.n1669 2.2361
R2462 vss.n1753 vss.n1668 2.2361
R2463 vss.n1753 vss.n1667 2.2361
R2464 vss.n1841 vss.n1766 2.2361
R2465 vss.n1841 vss.n1765 2.2361
R2466 vss.n1841 vss.n1764 2.2361
R2467 vss.n1841 vss.n1763 2.2361
R2468 vss.n1841 vss.n1762 2.2361
R2469 vss.n1841 vss.n1761 2.2361
R2470 vss.n1841 vss.n1760 2.2361
R2471 vss.n1841 vss.n1759 2.2361
R2472 vss.n1841 vss.n1758 2.2361
R2473 vss.n1841 vss.n1757 2.2361
R2474 vss.n1841 vss.n1756 2.2361
R2475 vss.n1841 vss.n1755 2.2361
R2476 vss.n1929 vss.n1854 2.2361
R2477 vss.n1929 vss.n1853 2.2361
R2478 vss.n1929 vss.n1852 2.2361
R2479 vss.n1929 vss.n1851 2.2361
R2480 vss.n1929 vss.n1850 2.2361
R2481 vss.n1929 vss.n1849 2.2361
R2482 vss.n1929 vss.n1848 2.2361
R2483 vss.n1929 vss.n1847 2.2361
R2484 vss.n1929 vss.n1846 2.2361
R2485 vss.n1929 vss.n1845 2.2361
R2486 vss.n1929 vss.n1844 2.2361
R2487 vss.n1929 vss.n1843 2.2361
R2488 vss.n2017 vss.n1942 2.2361
R2489 vss.n2017 vss.n1941 2.2361
R2490 vss.n2017 vss.n1940 2.2361
R2491 vss.n2017 vss.n1939 2.2361
R2492 vss.n2017 vss.n1938 2.2361
R2493 vss.n2017 vss.n1937 2.2361
R2494 vss.n2017 vss.n1936 2.2361
R2495 vss.n2017 vss.n1935 2.2361
R2496 vss.n2017 vss.n1934 2.2361
R2497 vss.n2017 vss.n1933 2.2361
R2498 vss.n2017 vss.n1932 2.2361
R2499 vss.n2017 vss.n1931 2.2361
R2500 vss.n2105 vss.n2030 2.2361
R2501 vss.n2105 vss.n2029 2.2361
R2502 vss.n2105 vss.n2028 2.2361
R2503 vss.n2105 vss.n2027 2.2361
R2504 vss.n2105 vss.n2026 2.2361
R2505 vss.n2105 vss.n2025 2.2361
R2506 vss.n2105 vss.n2024 2.2361
R2507 vss.n2105 vss.n2023 2.2361
R2508 vss.n2105 vss.n2022 2.2361
R2509 vss.n2105 vss.n2021 2.2361
R2510 vss.n2105 vss.n2020 2.2361
R2511 vss.n2105 vss.n2019 2.2361
R2512 vss.n2193 vss.n2118 2.2361
R2513 vss.n2193 vss.n2117 2.2361
R2514 vss.n2193 vss.n2116 2.2361
R2515 vss.n2193 vss.n2115 2.2361
R2516 vss.n2193 vss.n2114 2.2361
R2517 vss.n2193 vss.n2113 2.2361
R2518 vss.n2193 vss.n2112 2.2361
R2519 vss.n2193 vss.n2111 2.2361
R2520 vss.n2193 vss.n2110 2.2361
R2521 vss.n2193 vss.n2109 2.2361
R2522 vss.n2193 vss.n2108 2.2361
R2523 vss.n2193 vss.n2107 2.2361
R2524 vss.n2281 vss.n2206 2.2361
R2525 vss.n2281 vss.n2205 2.2361
R2526 vss.n2281 vss.n2204 2.2361
R2527 vss.n2281 vss.n2203 2.2361
R2528 vss.n2281 vss.n2202 2.2361
R2529 vss.n2281 vss.n2201 2.2361
R2530 vss.n2281 vss.n2200 2.2361
R2531 vss.n2281 vss.n2199 2.2361
R2532 vss.n2281 vss.n2198 2.2361
R2533 vss.n2281 vss.n2197 2.2361
R2534 vss.n2281 vss.n2196 2.2361
R2535 vss.n2281 vss.n2195 2.2361
R2536 vss.n2411 vss.n2336 2.2361
R2537 vss.n2411 vss.n2335 2.2361
R2538 vss.n2411 vss.n2334 2.2361
R2539 vss.n2411 vss.n2333 2.2361
R2540 vss.n2411 vss.n2332 2.2361
R2541 vss.n2411 vss.n2331 2.2361
R2542 vss.n2411 vss.n2330 2.2361
R2543 vss.n2411 vss.n2329 2.2361
R2544 vss.n2411 vss.n2328 2.2361
R2545 vss.n2411 vss.n2327 2.2361
R2546 vss.n2411 vss.n2326 2.2361
R2547 vss.n2411 vss.n2325 2.2361
R2548 vss.n2499 vss.n2424 2.2361
R2549 vss.n2499 vss.n2423 2.2361
R2550 vss.n2499 vss.n2422 2.2361
R2551 vss.n2499 vss.n2421 2.2361
R2552 vss.n2499 vss.n2420 2.2361
R2553 vss.n2499 vss.n2419 2.2361
R2554 vss.n2499 vss.n2418 2.2361
R2555 vss.n2499 vss.n2417 2.2361
R2556 vss.n2499 vss.n2416 2.2361
R2557 vss.n2499 vss.n2415 2.2361
R2558 vss.n2499 vss.n2414 2.2361
R2559 vss.n2499 vss.n2413 2.2361
R2560 vss.n2593 vss.n2518 2.2361
R2561 vss.n2593 vss.n2517 2.2361
R2562 vss.n2593 vss.n2516 2.2361
R2563 vss.n2593 vss.n2515 2.2361
R2564 vss.n2593 vss.n2514 2.2361
R2565 vss.n2593 vss.n2513 2.2361
R2566 vss.n2593 vss.n2512 2.2361
R2567 vss.n2593 vss.n2511 2.2361
R2568 vss.n2593 vss.n2510 2.2361
R2569 vss.n2593 vss.n2509 2.2361
R2570 vss.n2593 vss.n2508 2.2361
R2571 vss.n2593 vss.n2507 2.2361
R2572 vss.n2681 vss.n2606 2.2361
R2573 vss.n2681 vss.n2605 2.2361
R2574 vss.n2681 vss.n2604 2.2361
R2575 vss.n2681 vss.n2603 2.2361
R2576 vss.n2681 vss.n2602 2.2361
R2577 vss.n2681 vss.n2601 2.2361
R2578 vss.n2681 vss.n2600 2.2361
R2579 vss.n2681 vss.n2599 2.2361
R2580 vss.n2681 vss.n2598 2.2361
R2581 vss.n2681 vss.n2597 2.2361
R2582 vss.n2681 vss.n2596 2.2361
R2583 vss.n2681 vss.n2595 2.2361
R2584 vss.n2769 vss.n2694 2.2361
R2585 vss.n2769 vss.n2693 2.2361
R2586 vss.n2769 vss.n2692 2.2361
R2587 vss.n2769 vss.n2691 2.2361
R2588 vss.n2769 vss.n2690 2.2361
R2589 vss.n2769 vss.n2689 2.2361
R2590 vss.n2769 vss.n2688 2.2361
R2591 vss.n2769 vss.n2687 2.2361
R2592 vss.n2769 vss.n2686 2.2361
R2593 vss.n2769 vss.n2685 2.2361
R2594 vss.n2769 vss.n2684 2.2361
R2595 vss.n2769 vss.n2683 2.2361
R2596 vss.n2857 vss.n2782 2.2361
R2597 vss.n2857 vss.n2781 2.2361
R2598 vss.n2857 vss.n2780 2.2361
R2599 vss.n2857 vss.n2779 2.2361
R2600 vss.n2857 vss.n2778 2.2361
R2601 vss.n2857 vss.n2777 2.2361
R2602 vss.n2857 vss.n2776 2.2361
R2603 vss.n2857 vss.n2775 2.2361
R2604 vss.n2857 vss.n2774 2.2361
R2605 vss.n2857 vss.n2773 2.2361
R2606 vss.n2857 vss.n2772 2.2361
R2607 vss.n2857 vss.n2771 2.2361
R2608 vss.n119 vss.n86 2.2361
R2609 vss.n119 vss.n85 2.2361
R2610 vss.n119 vss.n84 2.2361
R2611 vss.n119 vss.n83 2.2361
R2612 vss.n119 vss.n82 2.2361
R2613 vss.n77 vss.n70 2.2361
R2614 vss.n139 vss.n124 2.2361
R2615 vss.n139 vss.n123 2.2361
R2616 vss.n127 vss.t7 2.12675
R2617 vss.n2289 vss.n2284 2.066
R2618 vss.n2503 vss.n121 1.7969
R2619 vss.n2861 vss.n2505 1.7969
R2620 vss.n2977 vss.t43 1.74637
R2621 vss.n2864 vss.n80 1.7105
R2622 vss.n2288 vss.n2287 1.52254
R2623 vss.t2 vss.n2976 1.43301
R2624 vss.n2975 vss.n2871 1.3937
R2625 vss.n141 vss.n68 1.3505
R2626 vss.n2868 vss.n80 1.1921
R2627 vss.n2978 vss.n69 1.1705
R2628 vss.n3009 vss.n68 1.0913
R2629 vss.n106 vss.t9 1.06363
R2630 vss.n3006 vss.n69 1.0409
R2631 vss.n3007 vss.t56 0.716753
R2632 vss.t4 vss.n120 0.53769
R2633 vss.n1522 vss.t27 0.526097
R2634 vss.n1434 vss.t28 0.526097
R2635 vss.n1346 vss.t29 0.526097
R2636 vss.n1258 vss.t30 0.526097
R2637 vss.n1170 vss.t31 0.526097
R2638 vss.n1082 vss.t32 0.526097
R2639 vss.n994 vss.t33 0.526097
R2640 vss.n906 vss.t34 0.526097
R2641 vss.n818 vss.t35 0.526097
R2642 vss.n730 vss.t36 0.526097
R2643 vss.n642 vss.t37 0.526097
R2644 vss.n554 vss.t38 0.526097
R2645 vss.n466 vss.t39 0.526097
R2646 vss.n378 vss.t40 0.526097
R2647 vss.n290 vss.t41 0.526097
R2648 vss.n202 vss.t42 0.526097
R2649 vss.n2249 vss.t19 0.526097
R2650 vss.n2161 vss.t20 0.526097
R2651 vss.n2073 vss.t11 0.526097
R2652 vss.n1985 vss.t21 0.526097
R2653 vss.n1897 vss.t22 0.526097
R2654 vss.n1809 vss.t23 0.526097
R2655 vss.n1721 vss.t24 0.526097
R2656 vss.n1633 vss.t25 0.526097
R2657 vss.n2467 vss.t13 0.526097
R2658 vss.n2379 vss.t14 0.526097
R2659 vss.n2825 vss.t15 0.526097
R2660 vss.n2737 vss.t16 0.526097
R2661 vss.n2649 vss.t17 0.526097
R2662 vss.n2561 vss.t18 0.526097
R2663 vss.n2940 vss.t5 0.526097
R2664 vss.n2317 vss.n2316 0.30101
R2665 vss.n2292 vss.n2290 0.2795
R2666 vss.n2502 vss.n18 0.25259
R2667 vss.n2859 vss.n6 0.25259
R2668 vss.n2318 vss.n2317 0.22856
R2669 vss.n2979 vss.n77 0.215214
R2670 vss.n2973 vss.n30 0.21227
R2671 vss.n2290 vss.n1577 0.20705
R2672 vss.n2867 vss.n42 0.19211
R2673 vss.n3013 vss.n3010 0.18203
R2674 vss.n2502 vss.n2501 0.18014
R2675 vss.n2860 vss.n2859 0.18014
R2676 vss.n3005 vss.n3004 0.17699
R2677 vss.n2310 vss.n2309 0.152
R2678 vss.n2974 vss.n2973 0.13982
R2679 vss.n140 vss.n139 0.137136
R2680 vss.n2867 vss.n2866 0.11966
R2681 vss.n3010 vss.n67 0.10958
R2682 vss.n3005 vss.n2980 0.10454
R2683 vss.n2866 vss.n2865 0.0995
R2684 vss.n140 vss.n67 0.0815
R2685 vss.n2865 vss.n119 0.0796053
R2686 vss vss.n3065 0.075625
R2687 vss.n2980 vss.n2979 0.0725
R2688 vss.n3055 vss.n3053 0.0695
R2689 vss.n1555 vss.n1554 0.0691571
R2690 vss.n2282 vss.n2281 0.0691571
R2691 vss.n2500 vss.n2499 0.0691571
R2692 vss.n2858 vss.n2857 0.0691571
R2693 vss.n2974 vss.n2972 0.062671
R2694 vss.n1500 vss.n1492 0.0605
R2695 vss.n1501 vss.n1500 0.0605
R2696 vss.n1502 vss.n1501 0.0605
R2697 vss.n1502 vss.n1490 0.0605
R2698 vss.n1510 vss.n1490 0.0605
R2699 vss.n1511 vss.n1510 0.0605
R2700 vss.n1512 vss.n1511 0.0605
R2701 vss.n1512 vss.n1488 0.0605
R2702 vss.n1520 vss.n1488 0.0605
R2703 vss.n1521 vss.n1520 0.0605
R2704 vss.n1523 vss.n1486 0.0605
R2705 vss.n1531 vss.n1486 0.0605
R2706 vss.n1532 vss.n1531 0.0605
R2707 vss.n1533 vss.n1532 0.0605
R2708 vss.n1533 vss.n1484 0.0605
R2709 vss.n1541 vss.n1484 0.0605
R2710 vss.n1542 vss.n1541 0.0605
R2711 vss.n1543 vss.n1542 0.0605
R2712 vss.n1543 vss.n1482 0.0605
R2713 vss.n1551 vss.n1482 0.0605
R2714 vss.n1496 vss.n1495 0.0605
R2715 vss.n1499 vss.n1496 0.0605
R2716 vss.n1499 vss.n1491 0.0605
R2717 vss.n1505 vss.n1491 0.0605
R2718 vss.n1506 vss.n1505 0.0605
R2719 vss.n1509 vss.n1506 0.0605
R2720 vss.n1509 vss.n1489 0.0605
R2721 vss.n1515 vss.n1489 0.0605
R2722 vss.n1516 vss.n1515 0.0605
R2723 vss.n1519 vss.n1516 0.0605
R2724 vss.n1519 vss.n1487 0.0605
R2725 vss.n1526 vss.n1487 0.0605
R2726 vss.n1527 vss.n1526 0.0605
R2727 vss.n1530 vss.n1527 0.0605
R2728 vss.n1530 vss.n1485 0.0605
R2729 vss.n1536 vss.n1485 0.0605
R2730 vss.n1537 vss.n1536 0.0605
R2731 vss.n1540 vss.n1537 0.0605
R2732 vss.n1540 vss.n1483 0.0605
R2733 vss.n1546 vss.n1483 0.0605
R2734 vss.n1547 vss.n1546 0.0605
R2735 vss.n1550 vss.n1547 0.0605
R2736 vss.n1550 vss.n1481 0.0605
R2737 vss.n1494 vss.n1467 0.0605
R2738 vss.n1498 vss.n1497 0.0605
R2739 vss.n1504 vss.n1503 0.0605
R2740 vss.n1508 vss.n1507 0.0605
R2741 vss.n1514 vss.n1513 0.0605
R2742 vss.n1518 vss.n1517 0.0605
R2743 vss.n1525 vss.n1524 0.0605
R2744 vss.n1529 vss.n1528 0.0605
R2745 vss.n1535 vss.n1534 0.0605
R2746 vss.n1539 vss.n1538 0.0605
R2747 vss.n1545 vss.n1544 0.0605
R2748 vss.n1549 vss.n1548 0.0605
R2749 vss.n1553 vss.n1480 0.0605
R2750 vss.n1412 vss.n1404 0.0605
R2751 vss.n1413 vss.n1412 0.0605
R2752 vss.n1414 vss.n1413 0.0605
R2753 vss.n1414 vss.n1402 0.0605
R2754 vss.n1422 vss.n1402 0.0605
R2755 vss.n1423 vss.n1422 0.0605
R2756 vss.n1424 vss.n1423 0.0605
R2757 vss.n1424 vss.n1400 0.0605
R2758 vss.n1432 vss.n1400 0.0605
R2759 vss.n1433 vss.n1432 0.0605
R2760 vss.n1435 vss.n1398 0.0605
R2761 vss.n1443 vss.n1398 0.0605
R2762 vss.n1444 vss.n1443 0.0605
R2763 vss.n1445 vss.n1444 0.0605
R2764 vss.n1445 vss.n1396 0.0605
R2765 vss.n1453 vss.n1396 0.0605
R2766 vss.n1454 vss.n1453 0.0605
R2767 vss.n1455 vss.n1454 0.0605
R2768 vss.n1455 vss.n1394 0.0605
R2769 vss.n1463 vss.n1394 0.0605
R2770 vss.n1408 vss.n1407 0.0605
R2771 vss.n1411 vss.n1408 0.0605
R2772 vss.n1411 vss.n1403 0.0605
R2773 vss.n1417 vss.n1403 0.0605
R2774 vss.n1418 vss.n1417 0.0605
R2775 vss.n1421 vss.n1418 0.0605
R2776 vss.n1421 vss.n1401 0.0605
R2777 vss.n1427 vss.n1401 0.0605
R2778 vss.n1428 vss.n1427 0.0605
R2779 vss.n1431 vss.n1428 0.0605
R2780 vss.n1431 vss.n1399 0.0605
R2781 vss.n1438 vss.n1399 0.0605
R2782 vss.n1439 vss.n1438 0.0605
R2783 vss.n1442 vss.n1439 0.0605
R2784 vss.n1442 vss.n1397 0.0605
R2785 vss.n1448 vss.n1397 0.0605
R2786 vss.n1449 vss.n1448 0.0605
R2787 vss.n1452 vss.n1449 0.0605
R2788 vss.n1452 vss.n1395 0.0605
R2789 vss.n1458 vss.n1395 0.0605
R2790 vss.n1459 vss.n1458 0.0605
R2791 vss.n1462 vss.n1459 0.0605
R2792 vss.n1462 vss.n1393 0.0605
R2793 vss.n1406 vss.n1379 0.0605
R2794 vss.n1410 vss.n1409 0.0605
R2795 vss.n1416 vss.n1415 0.0605
R2796 vss.n1420 vss.n1419 0.0605
R2797 vss.n1426 vss.n1425 0.0605
R2798 vss.n1430 vss.n1429 0.0605
R2799 vss.n1437 vss.n1436 0.0605
R2800 vss.n1441 vss.n1440 0.0605
R2801 vss.n1447 vss.n1446 0.0605
R2802 vss.n1451 vss.n1450 0.0605
R2803 vss.n1457 vss.n1456 0.0605
R2804 vss.n1461 vss.n1460 0.0605
R2805 vss.n1465 vss.n1392 0.0605
R2806 vss.n1324 vss.n1316 0.0605
R2807 vss.n1325 vss.n1324 0.0605
R2808 vss.n1326 vss.n1325 0.0605
R2809 vss.n1326 vss.n1314 0.0605
R2810 vss.n1334 vss.n1314 0.0605
R2811 vss.n1335 vss.n1334 0.0605
R2812 vss.n1336 vss.n1335 0.0605
R2813 vss.n1336 vss.n1312 0.0605
R2814 vss.n1344 vss.n1312 0.0605
R2815 vss.n1345 vss.n1344 0.0605
R2816 vss.n1347 vss.n1310 0.0605
R2817 vss.n1355 vss.n1310 0.0605
R2818 vss.n1356 vss.n1355 0.0605
R2819 vss.n1357 vss.n1356 0.0605
R2820 vss.n1357 vss.n1308 0.0605
R2821 vss.n1365 vss.n1308 0.0605
R2822 vss.n1366 vss.n1365 0.0605
R2823 vss.n1367 vss.n1366 0.0605
R2824 vss.n1367 vss.n1306 0.0605
R2825 vss.n1375 vss.n1306 0.0605
R2826 vss.n1320 vss.n1319 0.0605
R2827 vss.n1323 vss.n1320 0.0605
R2828 vss.n1323 vss.n1315 0.0605
R2829 vss.n1329 vss.n1315 0.0605
R2830 vss.n1330 vss.n1329 0.0605
R2831 vss.n1333 vss.n1330 0.0605
R2832 vss.n1333 vss.n1313 0.0605
R2833 vss.n1339 vss.n1313 0.0605
R2834 vss.n1340 vss.n1339 0.0605
R2835 vss.n1343 vss.n1340 0.0605
R2836 vss.n1343 vss.n1311 0.0605
R2837 vss.n1350 vss.n1311 0.0605
R2838 vss.n1351 vss.n1350 0.0605
R2839 vss.n1354 vss.n1351 0.0605
R2840 vss.n1354 vss.n1309 0.0605
R2841 vss.n1360 vss.n1309 0.0605
R2842 vss.n1361 vss.n1360 0.0605
R2843 vss.n1364 vss.n1361 0.0605
R2844 vss.n1364 vss.n1307 0.0605
R2845 vss.n1370 vss.n1307 0.0605
R2846 vss.n1371 vss.n1370 0.0605
R2847 vss.n1374 vss.n1371 0.0605
R2848 vss.n1374 vss.n1305 0.0605
R2849 vss.n1318 vss.n1291 0.0605
R2850 vss.n1322 vss.n1321 0.0605
R2851 vss.n1328 vss.n1327 0.0605
R2852 vss.n1332 vss.n1331 0.0605
R2853 vss.n1338 vss.n1337 0.0605
R2854 vss.n1342 vss.n1341 0.0605
R2855 vss.n1349 vss.n1348 0.0605
R2856 vss.n1353 vss.n1352 0.0605
R2857 vss.n1359 vss.n1358 0.0605
R2858 vss.n1363 vss.n1362 0.0605
R2859 vss.n1369 vss.n1368 0.0605
R2860 vss.n1373 vss.n1372 0.0605
R2861 vss.n1377 vss.n1304 0.0605
R2862 vss.n1236 vss.n1228 0.0605
R2863 vss.n1237 vss.n1236 0.0605
R2864 vss.n1238 vss.n1237 0.0605
R2865 vss.n1238 vss.n1226 0.0605
R2866 vss.n1246 vss.n1226 0.0605
R2867 vss.n1247 vss.n1246 0.0605
R2868 vss.n1248 vss.n1247 0.0605
R2869 vss.n1248 vss.n1224 0.0605
R2870 vss.n1256 vss.n1224 0.0605
R2871 vss.n1257 vss.n1256 0.0605
R2872 vss.n1259 vss.n1222 0.0605
R2873 vss.n1267 vss.n1222 0.0605
R2874 vss.n1268 vss.n1267 0.0605
R2875 vss.n1269 vss.n1268 0.0605
R2876 vss.n1269 vss.n1220 0.0605
R2877 vss.n1277 vss.n1220 0.0605
R2878 vss.n1278 vss.n1277 0.0605
R2879 vss.n1279 vss.n1278 0.0605
R2880 vss.n1279 vss.n1218 0.0605
R2881 vss.n1287 vss.n1218 0.0605
R2882 vss.n1232 vss.n1231 0.0605
R2883 vss.n1235 vss.n1232 0.0605
R2884 vss.n1235 vss.n1227 0.0605
R2885 vss.n1241 vss.n1227 0.0605
R2886 vss.n1242 vss.n1241 0.0605
R2887 vss.n1245 vss.n1242 0.0605
R2888 vss.n1245 vss.n1225 0.0605
R2889 vss.n1251 vss.n1225 0.0605
R2890 vss.n1252 vss.n1251 0.0605
R2891 vss.n1255 vss.n1252 0.0605
R2892 vss.n1255 vss.n1223 0.0605
R2893 vss.n1262 vss.n1223 0.0605
R2894 vss.n1263 vss.n1262 0.0605
R2895 vss.n1266 vss.n1263 0.0605
R2896 vss.n1266 vss.n1221 0.0605
R2897 vss.n1272 vss.n1221 0.0605
R2898 vss.n1273 vss.n1272 0.0605
R2899 vss.n1276 vss.n1273 0.0605
R2900 vss.n1276 vss.n1219 0.0605
R2901 vss.n1282 vss.n1219 0.0605
R2902 vss.n1283 vss.n1282 0.0605
R2903 vss.n1286 vss.n1283 0.0605
R2904 vss.n1286 vss.n1217 0.0605
R2905 vss.n1230 vss.n1203 0.0605
R2906 vss.n1234 vss.n1233 0.0605
R2907 vss.n1240 vss.n1239 0.0605
R2908 vss.n1244 vss.n1243 0.0605
R2909 vss.n1250 vss.n1249 0.0605
R2910 vss.n1254 vss.n1253 0.0605
R2911 vss.n1261 vss.n1260 0.0605
R2912 vss.n1265 vss.n1264 0.0605
R2913 vss.n1271 vss.n1270 0.0605
R2914 vss.n1275 vss.n1274 0.0605
R2915 vss.n1281 vss.n1280 0.0605
R2916 vss.n1285 vss.n1284 0.0605
R2917 vss.n1289 vss.n1216 0.0605
R2918 vss.n1148 vss.n1140 0.0605
R2919 vss.n1149 vss.n1148 0.0605
R2920 vss.n1150 vss.n1149 0.0605
R2921 vss.n1150 vss.n1138 0.0605
R2922 vss.n1158 vss.n1138 0.0605
R2923 vss.n1159 vss.n1158 0.0605
R2924 vss.n1160 vss.n1159 0.0605
R2925 vss.n1160 vss.n1136 0.0605
R2926 vss.n1168 vss.n1136 0.0605
R2927 vss.n1169 vss.n1168 0.0605
R2928 vss.n1171 vss.n1134 0.0605
R2929 vss.n1179 vss.n1134 0.0605
R2930 vss.n1180 vss.n1179 0.0605
R2931 vss.n1181 vss.n1180 0.0605
R2932 vss.n1181 vss.n1132 0.0605
R2933 vss.n1189 vss.n1132 0.0605
R2934 vss.n1190 vss.n1189 0.0605
R2935 vss.n1191 vss.n1190 0.0605
R2936 vss.n1191 vss.n1130 0.0605
R2937 vss.n1199 vss.n1130 0.0605
R2938 vss.n1144 vss.n1143 0.0605
R2939 vss.n1147 vss.n1144 0.0605
R2940 vss.n1147 vss.n1139 0.0605
R2941 vss.n1153 vss.n1139 0.0605
R2942 vss.n1154 vss.n1153 0.0605
R2943 vss.n1157 vss.n1154 0.0605
R2944 vss.n1157 vss.n1137 0.0605
R2945 vss.n1163 vss.n1137 0.0605
R2946 vss.n1164 vss.n1163 0.0605
R2947 vss.n1167 vss.n1164 0.0605
R2948 vss.n1167 vss.n1135 0.0605
R2949 vss.n1174 vss.n1135 0.0605
R2950 vss.n1175 vss.n1174 0.0605
R2951 vss.n1178 vss.n1175 0.0605
R2952 vss.n1178 vss.n1133 0.0605
R2953 vss.n1184 vss.n1133 0.0605
R2954 vss.n1185 vss.n1184 0.0605
R2955 vss.n1188 vss.n1185 0.0605
R2956 vss.n1188 vss.n1131 0.0605
R2957 vss.n1194 vss.n1131 0.0605
R2958 vss.n1195 vss.n1194 0.0605
R2959 vss.n1198 vss.n1195 0.0605
R2960 vss.n1198 vss.n1129 0.0605
R2961 vss.n1142 vss.n1115 0.0605
R2962 vss.n1146 vss.n1145 0.0605
R2963 vss.n1152 vss.n1151 0.0605
R2964 vss.n1156 vss.n1155 0.0605
R2965 vss.n1162 vss.n1161 0.0605
R2966 vss.n1166 vss.n1165 0.0605
R2967 vss.n1173 vss.n1172 0.0605
R2968 vss.n1177 vss.n1176 0.0605
R2969 vss.n1183 vss.n1182 0.0605
R2970 vss.n1187 vss.n1186 0.0605
R2971 vss.n1193 vss.n1192 0.0605
R2972 vss.n1197 vss.n1196 0.0605
R2973 vss.n1201 vss.n1128 0.0605
R2974 vss.n1060 vss.n1052 0.0605
R2975 vss.n1061 vss.n1060 0.0605
R2976 vss.n1062 vss.n1061 0.0605
R2977 vss.n1062 vss.n1050 0.0605
R2978 vss.n1070 vss.n1050 0.0605
R2979 vss.n1071 vss.n1070 0.0605
R2980 vss.n1072 vss.n1071 0.0605
R2981 vss.n1072 vss.n1048 0.0605
R2982 vss.n1080 vss.n1048 0.0605
R2983 vss.n1081 vss.n1080 0.0605
R2984 vss.n1083 vss.n1046 0.0605
R2985 vss.n1091 vss.n1046 0.0605
R2986 vss.n1092 vss.n1091 0.0605
R2987 vss.n1093 vss.n1092 0.0605
R2988 vss.n1093 vss.n1044 0.0605
R2989 vss.n1101 vss.n1044 0.0605
R2990 vss.n1102 vss.n1101 0.0605
R2991 vss.n1103 vss.n1102 0.0605
R2992 vss.n1103 vss.n1042 0.0605
R2993 vss.n1111 vss.n1042 0.0605
R2994 vss.n1056 vss.n1055 0.0605
R2995 vss.n1059 vss.n1056 0.0605
R2996 vss.n1059 vss.n1051 0.0605
R2997 vss.n1065 vss.n1051 0.0605
R2998 vss.n1066 vss.n1065 0.0605
R2999 vss.n1069 vss.n1066 0.0605
R3000 vss.n1069 vss.n1049 0.0605
R3001 vss.n1075 vss.n1049 0.0605
R3002 vss.n1076 vss.n1075 0.0605
R3003 vss.n1079 vss.n1076 0.0605
R3004 vss.n1079 vss.n1047 0.0605
R3005 vss.n1086 vss.n1047 0.0605
R3006 vss.n1087 vss.n1086 0.0605
R3007 vss.n1090 vss.n1087 0.0605
R3008 vss.n1090 vss.n1045 0.0605
R3009 vss.n1096 vss.n1045 0.0605
R3010 vss.n1097 vss.n1096 0.0605
R3011 vss.n1100 vss.n1097 0.0605
R3012 vss.n1100 vss.n1043 0.0605
R3013 vss.n1106 vss.n1043 0.0605
R3014 vss.n1107 vss.n1106 0.0605
R3015 vss.n1110 vss.n1107 0.0605
R3016 vss.n1110 vss.n1041 0.0605
R3017 vss.n1054 vss.n1027 0.0605
R3018 vss.n1058 vss.n1057 0.0605
R3019 vss.n1064 vss.n1063 0.0605
R3020 vss.n1068 vss.n1067 0.0605
R3021 vss.n1074 vss.n1073 0.0605
R3022 vss.n1078 vss.n1077 0.0605
R3023 vss.n1085 vss.n1084 0.0605
R3024 vss.n1089 vss.n1088 0.0605
R3025 vss.n1095 vss.n1094 0.0605
R3026 vss.n1099 vss.n1098 0.0605
R3027 vss.n1105 vss.n1104 0.0605
R3028 vss.n1109 vss.n1108 0.0605
R3029 vss.n1113 vss.n1040 0.0605
R3030 vss.n972 vss.n964 0.0605
R3031 vss.n973 vss.n972 0.0605
R3032 vss.n974 vss.n973 0.0605
R3033 vss.n974 vss.n962 0.0605
R3034 vss.n982 vss.n962 0.0605
R3035 vss.n983 vss.n982 0.0605
R3036 vss.n984 vss.n983 0.0605
R3037 vss.n984 vss.n960 0.0605
R3038 vss.n992 vss.n960 0.0605
R3039 vss.n993 vss.n992 0.0605
R3040 vss.n995 vss.n958 0.0605
R3041 vss.n1003 vss.n958 0.0605
R3042 vss.n1004 vss.n1003 0.0605
R3043 vss.n1005 vss.n1004 0.0605
R3044 vss.n1005 vss.n956 0.0605
R3045 vss.n1013 vss.n956 0.0605
R3046 vss.n1014 vss.n1013 0.0605
R3047 vss.n1015 vss.n1014 0.0605
R3048 vss.n1015 vss.n954 0.0605
R3049 vss.n1023 vss.n954 0.0605
R3050 vss.n968 vss.n967 0.0605
R3051 vss.n971 vss.n968 0.0605
R3052 vss.n971 vss.n963 0.0605
R3053 vss.n977 vss.n963 0.0605
R3054 vss.n978 vss.n977 0.0605
R3055 vss.n981 vss.n978 0.0605
R3056 vss.n981 vss.n961 0.0605
R3057 vss.n987 vss.n961 0.0605
R3058 vss.n988 vss.n987 0.0605
R3059 vss.n991 vss.n988 0.0605
R3060 vss.n991 vss.n959 0.0605
R3061 vss.n998 vss.n959 0.0605
R3062 vss.n999 vss.n998 0.0605
R3063 vss.n1002 vss.n999 0.0605
R3064 vss.n1002 vss.n957 0.0605
R3065 vss.n1008 vss.n957 0.0605
R3066 vss.n1009 vss.n1008 0.0605
R3067 vss.n1012 vss.n1009 0.0605
R3068 vss.n1012 vss.n955 0.0605
R3069 vss.n1018 vss.n955 0.0605
R3070 vss.n1019 vss.n1018 0.0605
R3071 vss.n1022 vss.n1019 0.0605
R3072 vss.n1022 vss.n953 0.0605
R3073 vss.n966 vss.n939 0.0605
R3074 vss.n970 vss.n969 0.0605
R3075 vss.n976 vss.n975 0.0605
R3076 vss.n980 vss.n979 0.0605
R3077 vss.n986 vss.n985 0.0605
R3078 vss.n990 vss.n989 0.0605
R3079 vss.n997 vss.n996 0.0605
R3080 vss.n1001 vss.n1000 0.0605
R3081 vss.n1007 vss.n1006 0.0605
R3082 vss.n1011 vss.n1010 0.0605
R3083 vss.n1017 vss.n1016 0.0605
R3084 vss.n1021 vss.n1020 0.0605
R3085 vss.n1025 vss.n952 0.0605
R3086 vss.n884 vss.n876 0.0605
R3087 vss.n885 vss.n884 0.0605
R3088 vss.n886 vss.n885 0.0605
R3089 vss.n886 vss.n874 0.0605
R3090 vss.n894 vss.n874 0.0605
R3091 vss.n895 vss.n894 0.0605
R3092 vss.n896 vss.n895 0.0605
R3093 vss.n896 vss.n872 0.0605
R3094 vss.n904 vss.n872 0.0605
R3095 vss.n905 vss.n904 0.0605
R3096 vss.n907 vss.n870 0.0605
R3097 vss.n915 vss.n870 0.0605
R3098 vss.n916 vss.n915 0.0605
R3099 vss.n917 vss.n916 0.0605
R3100 vss.n917 vss.n868 0.0605
R3101 vss.n925 vss.n868 0.0605
R3102 vss.n926 vss.n925 0.0605
R3103 vss.n927 vss.n926 0.0605
R3104 vss.n927 vss.n866 0.0605
R3105 vss.n935 vss.n866 0.0605
R3106 vss.n880 vss.n879 0.0605
R3107 vss.n883 vss.n880 0.0605
R3108 vss.n883 vss.n875 0.0605
R3109 vss.n889 vss.n875 0.0605
R3110 vss.n890 vss.n889 0.0605
R3111 vss.n893 vss.n890 0.0605
R3112 vss.n893 vss.n873 0.0605
R3113 vss.n899 vss.n873 0.0605
R3114 vss.n900 vss.n899 0.0605
R3115 vss.n903 vss.n900 0.0605
R3116 vss.n903 vss.n871 0.0605
R3117 vss.n910 vss.n871 0.0605
R3118 vss.n911 vss.n910 0.0605
R3119 vss.n914 vss.n911 0.0605
R3120 vss.n914 vss.n869 0.0605
R3121 vss.n920 vss.n869 0.0605
R3122 vss.n921 vss.n920 0.0605
R3123 vss.n924 vss.n921 0.0605
R3124 vss.n924 vss.n867 0.0605
R3125 vss.n930 vss.n867 0.0605
R3126 vss.n931 vss.n930 0.0605
R3127 vss.n934 vss.n931 0.0605
R3128 vss.n934 vss.n865 0.0605
R3129 vss.n878 vss.n851 0.0605
R3130 vss.n882 vss.n881 0.0605
R3131 vss.n888 vss.n887 0.0605
R3132 vss.n892 vss.n891 0.0605
R3133 vss.n898 vss.n897 0.0605
R3134 vss.n902 vss.n901 0.0605
R3135 vss.n909 vss.n908 0.0605
R3136 vss.n913 vss.n912 0.0605
R3137 vss.n919 vss.n918 0.0605
R3138 vss.n923 vss.n922 0.0605
R3139 vss.n929 vss.n928 0.0605
R3140 vss.n933 vss.n932 0.0605
R3141 vss.n937 vss.n864 0.0605
R3142 vss.n796 vss.n788 0.0605
R3143 vss.n797 vss.n796 0.0605
R3144 vss.n798 vss.n797 0.0605
R3145 vss.n798 vss.n786 0.0605
R3146 vss.n806 vss.n786 0.0605
R3147 vss.n807 vss.n806 0.0605
R3148 vss.n808 vss.n807 0.0605
R3149 vss.n808 vss.n784 0.0605
R3150 vss.n816 vss.n784 0.0605
R3151 vss.n817 vss.n816 0.0605
R3152 vss.n819 vss.n782 0.0605
R3153 vss.n827 vss.n782 0.0605
R3154 vss.n828 vss.n827 0.0605
R3155 vss.n829 vss.n828 0.0605
R3156 vss.n829 vss.n780 0.0605
R3157 vss.n837 vss.n780 0.0605
R3158 vss.n838 vss.n837 0.0605
R3159 vss.n839 vss.n838 0.0605
R3160 vss.n839 vss.n778 0.0605
R3161 vss.n847 vss.n778 0.0605
R3162 vss.n792 vss.n791 0.0605
R3163 vss.n795 vss.n792 0.0605
R3164 vss.n795 vss.n787 0.0605
R3165 vss.n801 vss.n787 0.0605
R3166 vss.n802 vss.n801 0.0605
R3167 vss.n805 vss.n802 0.0605
R3168 vss.n805 vss.n785 0.0605
R3169 vss.n811 vss.n785 0.0605
R3170 vss.n812 vss.n811 0.0605
R3171 vss.n815 vss.n812 0.0605
R3172 vss.n815 vss.n783 0.0605
R3173 vss.n822 vss.n783 0.0605
R3174 vss.n823 vss.n822 0.0605
R3175 vss.n826 vss.n823 0.0605
R3176 vss.n826 vss.n781 0.0605
R3177 vss.n832 vss.n781 0.0605
R3178 vss.n833 vss.n832 0.0605
R3179 vss.n836 vss.n833 0.0605
R3180 vss.n836 vss.n779 0.0605
R3181 vss.n842 vss.n779 0.0605
R3182 vss.n843 vss.n842 0.0605
R3183 vss.n846 vss.n843 0.0605
R3184 vss.n846 vss.n777 0.0605
R3185 vss.n790 vss.n763 0.0605
R3186 vss.n794 vss.n793 0.0605
R3187 vss.n800 vss.n799 0.0605
R3188 vss.n804 vss.n803 0.0605
R3189 vss.n810 vss.n809 0.0605
R3190 vss.n814 vss.n813 0.0605
R3191 vss.n821 vss.n820 0.0605
R3192 vss.n825 vss.n824 0.0605
R3193 vss.n831 vss.n830 0.0605
R3194 vss.n835 vss.n834 0.0605
R3195 vss.n841 vss.n840 0.0605
R3196 vss.n845 vss.n844 0.0605
R3197 vss.n849 vss.n776 0.0605
R3198 vss.n708 vss.n700 0.0605
R3199 vss.n709 vss.n708 0.0605
R3200 vss.n710 vss.n709 0.0605
R3201 vss.n710 vss.n698 0.0605
R3202 vss.n718 vss.n698 0.0605
R3203 vss.n719 vss.n718 0.0605
R3204 vss.n720 vss.n719 0.0605
R3205 vss.n720 vss.n696 0.0605
R3206 vss.n728 vss.n696 0.0605
R3207 vss.n729 vss.n728 0.0605
R3208 vss.n731 vss.n694 0.0605
R3209 vss.n739 vss.n694 0.0605
R3210 vss.n740 vss.n739 0.0605
R3211 vss.n741 vss.n740 0.0605
R3212 vss.n741 vss.n692 0.0605
R3213 vss.n749 vss.n692 0.0605
R3214 vss.n750 vss.n749 0.0605
R3215 vss.n751 vss.n750 0.0605
R3216 vss.n751 vss.n690 0.0605
R3217 vss.n759 vss.n690 0.0605
R3218 vss.n704 vss.n703 0.0605
R3219 vss.n707 vss.n704 0.0605
R3220 vss.n707 vss.n699 0.0605
R3221 vss.n713 vss.n699 0.0605
R3222 vss.n714 vss.n713 0.0605
R3223 vss.n717 vss.n714 0.0605
R3224 vss.n717 vss.n697 0.0605
R3225 vss.n723 vss.n697 0.0605
R3226 vss.n724 vss.n723 0.0605
R3227 vss.n727 vss.n724 0.0605
R3228 vss.n727 vss.n695 0.0605
R3229 vss.n734 vss.n695 0.0605
R3230 vss.n735 vss.n734 0.0605
R3231 vss.n738 vss.n735 0.0605
R3232 vss.n738 vss.n693 0.0605
R3233 vss.n744 vss.n693 0.0605
R3234 vss.n745 vss.n744 0.0605
R3235 vss.n748 vss.n745 0.0605
R3236 vss.n748 vss.n691 0.0605
R3237 vss.n754 vss.n691 0.0605
R3238 vss.n755 vss.n754 0.0605
R3239 vss.n758 vss.n755 0.0605
R3240 vss.n758 vss.n689 0.0605
R3241 vss.n702 vss.n675 0.0605
R3242 vss.n706 vss.n705 0.0605
R3243 vss.n712 vss.n711 0.0605
R3244 vss.n716 vss.n715 0.0605
R3245 vss.n722 vss.n721 0.0605
R3246 vss.n726 vss.n725 0.0605
R3247 vss.n733 vss.n732 0.0605
R3248 vss.n737 vss.n736 0.0605
R3249 vss.n743 vss.n742 0.0605
R3250 vss.n747 vss.n746 0.0605
R3251 vss.n753 vss.n752 0.0605
R3252 vss.n757 vss.n756 0.0605
R3253 vss.n761 vss.n688 0.0605
R3254 vss.n620 vss.n612 0.0605
R3255 vss.n621 vss.n620 0.0605
R3256 vss.n622 vss.n621 0.0605
R3257 vss.n622 vss.n610 0.0605
R3258 vss.n630 vss.n610 0.0605
R3259 vss.n631 vss.n630 0.0605
R3260 vss.n632 vss.n631 0.0605
R3261 vss.n632 vss.n608 0.0605
R3262 vss.n640 vss.n608 0.0605
R3263 vss.n641 vss.n640 0.0605
R3264 vss.n643 vss.n606 0.0605
R3265 vss.n651 vss.n606 0.0605
R3266 vss.n652 vss.n651 0.0605
R3267 vss.n653 vss.n652 0.0605
R3268 vss.n653 vss.n604 0.0605
R3269 vss.n661 vss.n604 0.0605
R3270 vss.n662 vss.n661 0.0605
R3271 vss.n663 vss.n662 0.0605
R3272 vss.n663 vss.n602 0.0605
R3273 vss.n671 vss.n602 0.0605
R3274 vss.n616 vss.n615 0.0605
R3275 vss.n619 vss.n616 0.0605
R3276 vss.n619 vss.n611 0.0605
R3277 vss.n625 vss.n611 0.0605
R3278 vss.n626 vss.n625 0.0605
R3279 vss.n629 vss.n626 0.0605
R3280 vss.n629 vss.n609 0.0605
R3281 vss.n635 vss.n609 0.0605
R3282 vss.n636 vss.n635 0.0605
R3283 vss.n639 vss.n636 0.0605
R3284 vss.n639 vss.n607 0.0605
R3285 vss.n646 vss.n607 0.0605
R3286 vss.n647 vss.n646 0.0605
R3287 vss.n650 vss.n647 0.0605
R3288 vss.n650 vss.n605 0.0605
R3289 vss.n656 vss.n605 0.0605
R3290 vss.n657 vss.n656 0.0605
R3291 vss.n660 vss.n657 0.0605
R3292 vss.n660 vss.n603 0.0605
R3293 vss.n666 vss.n603 0.0605
R3294 vss.n667 vss.n666 0.0605
R3295 vss.n670 vss.n667 0.0605
R3296 vss.n670 vss.n601 0.0605
R3297 vss.n614 vss.n587 0.0605
R3298 vss.n618 vss.n617 0.0605
R3299 vss.n624 vss.n623 0.0605
R3300 vss.n628 vss.n627 0.0605
R3301 vss.n634 vss.n633 0.0605
R3302 vss.n638 vss.n637 0.0605
R3303 vss.n645 vss.n644 0.0605
R3304 vss.n649 vss.n648 0.0605
R3305 vss.n655 vss.n654 0.0605
R3306 vss.n659 vss.n658 0.0605
R3307 vss.n665 vss.n664 0.0605
R3308 vss.n669 vss.n668 0.0605
R3309 vss.n673 vss.n600 0.0605
R3310 vss.n532 vss.n524 0.0605
R3311 vss.n533 vss.n532 0.0605
R3312 vss.n534 vss.n533 0.0605
R3313 vss.n534 vss.n522 0.0605
R3314 vss.n542 vss.n522 0.0605
R3315 vss.n543 vss.n542 0.0605
R3316 vss.n544 vss.n543 0.0605
R3317 vss.n544 vss.n520 0.0605
R3318 vss.n552 vss.n520 0.0605
R3319 vss.n553 vss.n552 0.0605
R3320 vss.n555 vss.n518 0.0605
R3321 vss.n563 vss.n518 0.0605
R3322 vss.n564 vss.n563 0.0605
R3323 vss.n565 vss.n564 0.0605
R3324 vss.n565 vss.n516 0.0605
R3325 vss.n573 vss.n516 0.0605
R3326 vss.n574 vss.n573 0.0605
R3327 vss.n575 vss.n574 0.0605
R3328 vss.n575 vss.n514 0.0605
R3329 vss.n583 vss.n514 0.0605
R3330 vss.n528 vss.n527 0.0605
R3331 vss.n531 vss.n528 0.0605
R3332 vss.n531 vss.n523 0.0605
R3333 vss.n537 vss.n523 0.0605
R3334 vss.n538 vss.n537 0.0605
R3335 vss.n541 vss.n538 0.0605
R3336 vss.n541 vss.n521 0.0605
R3337 vss.n547 vss.n521 0.0605
R3338 vss.n548 vss.n547 0.0605
R3339 vss.n551 vss.n548 0.0605
R3340 vss.n551 vss.n519 0.0605
R3341 vss.n558 vss.n519 0.0605
R3342 vss.n559 vss.n558 0.0605
R3343 vss.n562 vss.n559 0.0605
R3344 vss.n562 vss.n517 0.0605
R3345 vss.n568 vss.n517 0.0605
R3346 vss.n569 vss.n568 0.0605
R3347 vss.n572 vss.n569 0.0605
R3348 vss.n572 vss.n515 0.0605
R3349 vss.n578 vss.n515 0.0605
R3350 vss.n579 vss.n578 0.0605
R3351 vss.n582 vss.n579 0.0605
R3352 vss.n582 vss.n513 0.0605
R3353 vss.n526 vss.n499 0.0605
R3354 vss.n530 vss.n529 0.0605
R3355 vss.n536 vss.n535 0.0605
R3356 vss.n540 vss.n539 0.0605
R3357 vss.n546 vss.n545 0.0605
R3358 vss.n550 vss.n549 0.0605
R3359 vss.n557 vss.n556 0.0605
R3360 vss.n561 vss.n560 0.0605
R3361 vss.n567 vss.n566 0.0605
R3362 vss.n571 vss.n570 0.0605
R3363 vss.n577 vss.n576 0.0605
R3364 vss.n581 vss.n580 0.0605
R3365 vss.n585 vss.n512 0.0605
R3366 vss.n444 vss.n436 0.0605
R3367 vss.n445 vss.n444 0.0605
R3368 vss.n446 vss.n445 0.0605
R3369 vss.n446 vss.n434 0.0605
R3370 vss.n454 vss.n434 0.0605
R3371 vss.n455 vss.n454 0.0605
R3372 vss.n456 vss.n455 0.0605
R3373 vss.n456 vss.n432 0.0605
R3374 vss.n464 vss.n432 0.0605
R3375 vss.n465 vss.n464 0.0605
R3376 vss.n467 vss.n430 0.0605
R3377 vss.n475 vss.n430 0.0605
R3378 vss.n476 vss.n475 0.0605
R3379 vss.n477 vss.n476 0.0605
R3380 vss.n477 vss.n428 0.0605
R3381 vss.n485 vss.n428 0.0605
R3382 vss.n486 vss.n485 0.0605
R3383 vss.n487 vss.n486 0.0605
R3384 vss.n487 vss.n426 0.0605
R3385 vss.n495 vss.n426 0.0605
R3386 vss.n440 vss.n439 0.0605
R3387 vss.n443 vss.n440 0.0605
R3388 vss.n443 vss.n435 0.0605
R3389 vss.n449 vss.n435 0.0605
R3390 vss.n450 vss.n449 0.0605
R3391 vss.n453 vss.n450 0.0605
R3392 vss.n453 vss.n433 0.0605
R3393 vss.n459 vss.n433 0.0605
R3394 vss.n460 vss.n459 0.0605
R3395 vss.n463 vss.n460 0.0605
R3396 vss.n463 vss.n431 0.0605
R3397 vss.n470 vss.n431 0.0605
R3398 vss.n471 vss.n470 0.0605
R3399 vss.n474 vss.n471 0.0605
R3400 vss.n474 vss.n429 0.0605
R3401 vss.n480 vss.n429 0.0605
R3402 vss.n481 vss.n480 0.0605
R3403 vss.n484 vss.n481 0.0605
R3404 vss.n484 vss.n427 0.0605
R3405 vss.n490 vss.n427 0.0605
R3406 vss.n491 vss.n490 0.0605
R3407 vss.n494 vss.n491 0.0605
R3408 vss.n494 vss.n425 0.0605
R3409 vss.n438 vss.n411 0.0605
R3410 vss.n442 vss.n441 0.0605
R3411 vss.n448 vss.n447 0.0605
R3412 vss.n452 vss.n451 0.0605
R3413 vss.n458 vss.n457 0.0605
R3414 vss.n462 vss.n461 0.0605
R3415 vss.n469 vss.n468 0.0605
R3416 vss.n473 vss.n472 0.0605
R3417 vss.n479 vss.n478 0.0605
R3418 vss.n483 vss.n482 0.0605
R3419 vss.n489 vss.n488 0.0605
R3420 vss.n493 vss.n492 0.0605
R3421 vss.n497 vss.n424 0.0605
R3422 vss.n356 vss.n348 0.0605
R3423 vss.n357 vss.n356 0.0605
R3424 vss.n358 vss.n357 0.0605
R3425 vss.n358 vss.n346 0.0605
R3426 vss.n366 vss.n346 0.0605
R3427 vss.n367 vss.n366 0.0605
R3428 vss.n368 vss.n367 0.0605
R3429 vss.n368 vss.n344 0.0605
R3430 vss.n376 vss.n344 0.0605
R3431 vss.n377 vss.n376 0.0605
R3432 vss.n379 vss.n342 0.0605
R3433 vss.n387 vss.n342 0.0605
R3434 vss.n388 vss.n387 0.0605
R3435 vss.n389 vss.n388 0.0605
R3436 vss.n389 vss.n340 0.0605
R3437 vss.n397 vss.n340 0.0605
R3438 vss.n398 vss.n397 0.0605
R3439 vss.n399 vss.n398 0.0605
R3440 vss.n399 vss.n338 0.0605
R3441 vss.n407 vss.n338 0.0605
R3442 vss.n352 vss.n351 0.0605
R3443 vss.n355 vss.n352 0.0605
R3444 vss.n355 vss.n347 0.0605
R3445 vss.n361 vss.n347 0.0605
R3446 vss.n362 vss.n361 0.0605
R3447 vss.n365 vss.n362 0.0605
R3448 vss.n365 vss.n345 0.0605
R3449 vss.n371 vss.n345 0.0605
R3450 vss.n372 vss.n371 0.0605
R3451 vss.n375 vss.n372 0.0605
R3452 vss.n375 vss.n343 0.0605
R3453 vss.n382 vss.n343 0.0605
R3454 vss.n383 vss.n382 0.0605
R3455 vss.n386 vss.n383 0.0605
R3456 vss.n386 vss.n341 0.0605
R3457 vss.n392 vss.n341 0.0605
R3458 vss.n393 vss.n392 0.0605
R3459 vss.n396 vss.n393 0.0605
R3460 vss.n396 vss.n339 0.0605
R3461 vss.n402 vss.n339 0.0605
R3462 vss.n403 vss.n402 0.0605
R3463 vss.n406 vss.n403 0.0605
R3464 vss.n406 vss.n337 0.0605
R3465 vss.n350 vss.n323 0.0605
R3466 vss.n354 vss.n353 0.0605
R3467 vss.n360 vss.n359 0.0605
R3468 vss.n364 vss.n363 0.0605
R3469 vss.n370 vss.n369 0.0605
R3470 vss.n374 vss.n373 0.0605
R3471 vss.n381 vss.n380 0.0605
R3472 vss.n385 vss.n384 0.0605
R3473 vss.n391 vss.n390 0.0605
R3474 vss.n395 vss.n394 0.0605
R3475 vss.n401 vss.n400 0.0605
R3476 vss.n405 vss.n404 0.0605
R3477 vss.n409 vss.n336 0.0605
R3478 vss.n268 vss.n260 0.0605
R3479 vss.n269 vss.n268 0.0605
R3480 vss.n270 vss.n269 0.0605
R3481 vss.n270 vss.n258 0.0605
R3482 vss.n278 vss.n258 0.0605
R3483 vss.n279 vss.n278 0.0605
R3484 vss.n280 vss.n279 0.0605
R3485 vss.n280 vss.n256 0.0605
R3486 vss.n288 vss.n256 0.0605
R3487 vss.n289 vss.n288 0.0605
R3488 vss.n291 vss.n254 0.0605
R3489 vss.n299 vss.n254 0.0605
R3490 vss.n300 vss.n299 0.0605
R3491 vss.n301 vss.n300 0.0605
R3492 vss.n301 vss.n252 0.0605
R3493 vss.n309 vss.n252 0.0605
R3494 vss.n310 vss.n309 0.0605
R3495 vss.n311 vss.n310 0.0605
R3496 vss.n311 vss.n250 0.0605
R3497 vss.n319 vss.n250 0.0605
R3498 vss.n264 vss.n263 0.0605
R3499 vss.n267 vss.n264 0.0605
R3500 vss.n267 vss.n259 0.0605
R3501 vss.n273 vss.n259 0.0605
R3502 vss.n274 vss.n273 0.0605
R3503 vss.n277 vss.n274 0.0605
R3504 vss.n277 vss.n257 0.0605
R3505 vss.n283 vss.n257 0.0605
R3506 vss.n284 vss.n283 0.0605
R3507 vss.n287 vss.n284 0.0605
R3508 vss.n287 vss.n255 0.0605
R3509 vss.n294 vss.n255 0.0605
R3510 vss.n295 vss.n294 0.0605
R3511 vss.n298 vss.n295 0.0605
R3512 vss.n298 vss.n253 0.0605
R3513 vss.n304 vss.n253 0.0605
R3514 vss.n305 vss.n304 0.0605
R3515 vss.n308 vss.n305 0.0605
R3516 vss.n308 vss.n251 0.0605
R3517 vss.n314 vss.n251 0.0605
R3518 vss.n315 vss.n314 0.0605
R3519 vss.n318 vss.n315 0.0605
R3520 vss.n318 vss.n249 0.0605
R3521 vss.n262 vss.n235 0.0605
R3522 vss.n266 vss.n265 0.0605
R3523 vss.n272 vss.n271 0.0605
R3524 vss.n276 vss.n275 0.0605
R3525 vss.n282 vss.n281 0.0605
R3526 vss.n286 vss.n285 0.0605
R3527 vss.n293 vss.n292 0.0605
R3528 vss.n297 vss.n296 0.0605
R3529 vss.n303 vss.n302 0.0605
R3530 vss.n307 vss.n306 0.0605
R3531 vss.n313 vss.n312 0.0605
R3532 vss.n317 vss.n316 0.0605
R3533 vss.n321 vss.n248 0.0605
R3534 vss.n180 vss.n172 0.0605
R3535 vss.n181 vss.n180 0.0605
R3536 vss.n182 vss.n181 0.0605
R3537 vss.n182 vss.n170 0.0605
R3538 vss.n190 vss.n170 0.0605
R3539 vss.n191 vss.n190 0.0605
R3540 vss.n192 vss.n191 0.0605
R3541 vss.n192 vss.n168 0.0605
R3542 vss.n200 vss.n168 0.0605
R3543 vss.n201 vss.n200 0.0605
R3544 vss.n203 vss.n166 0.0605
R3545 vss.n211 vss.n166 0.0605
R3546 vss.n212 vss.n211 0.0605
R3547 vss.n213 vss.n212 0.0605
R3548 vss.n213 vss.n164 0.0605
R3549 vss.n221 vss.n164 0.0605
R3550 vss.n222 vss.n221 0.0605
R3551 vss.n223 vss.n222 0.0605
R3552 vss.n223 vss.n162 0.0605
R3553 vss.n231 vss.n162 0.0605
R3554 vss.n176 vss.n175 0.0605
R3555 vss.n179 vss.n176 0.0605
R3556 vss.n179 vss.n171 0.0605
R3557 vss.n185 vss.n171 0.0605
R3558 vss.n186 vss.n185 0.0605
R3559 vss.n189 vss.n186 0.0605
R3560 vss.n189 vss.n169 0.0605
R3561 vss.n195 vss.n169 0.0605
R3562 vss.n196 vss.n195 0.0605
R3563 vss.n199 vss.n196 0.0605
R3564 vss.n199 vss.n167 0.0605
R3565 vss.n206 vss.n167 0.0605
R3566 vss.n207 vss.n206 0.0605
R3567 vss.n210 vss.n207 0.0605
R3568 vss.n210 vss.n165 0.0605
R3569 vss.n216 vss.n165 0.0605
R3570 vss.n217 vss.n216 0.0605
R3571 vss.n220 vss.n217 0.0605
R3572 vss.n220 vss.n163 0.0605
R3573 vss.n226 vss.n163 0.0605
R3574 vss.n227 vss.n226 0.0605
R3575 vss.n230 vss.n227 0.0605
R3576 vss.n230 vss.n161 0.0605
R3577 vss.n174 vss.n147 0.0605
R3578 vss.n178 vss.n177 0.0605
R3579 vss.n184 vss.n183 0.0605
R3580 vss.n188 vss.n187 0.0605
R3581 vss.n194 vss.n193 0.0605
R3582 vss.n198 vss.n197 0.0605
R3583 vss.n205 vss.n204 0.0605
R3584 vss.n209 vss.n208 0.0605
R3585 vss.n215 vss.n214 0.0605
R3586 vss.n219 vss.n218 0.0605
R3587 vss.n225 vss.n224 0.0605
R3588 vss.n229 vss.n228 0.0605
R3589 vss.n233 vss.n160 0.0605
R3590 vss.n2227 vss.n2219 0.0605
R3591 vss.n2228 vss.n2227 0.0605
R3592 vss.n2229 vss.n2228 0.0605
R3593 vss.n2229 vss.n2217 0.0605
R3594 vss.n2237 vss.n2217 0.0605
R3595 vss.n2238 vss.n2237 0.0605
R3596 vss.n2239 vss.n2238 0.0605
R3597 vss.n2239 vss.n2215 0.0605
R3598 vss.n2247 vss.n2215 0.0605
R3599 vss.n2248 vss.n2247 0.0605
R3600 vss.n2250 vss.n2213 0.0605
R3601 vss.n2258 vss.n2213 0.0605
R3602 vss.n2259 vss.n2258 0.0605
R3603 vss.n2260 vss.n2259 0.0605
R3604 vss.n2260 vss.n2211 0.0605
R3605 vss.n2268 vss.n2211 0.0605
R3606 vss.n2269 vss.n2268 0.0605
R3607 vss.n2270 vss.n2269 0.0605
R3608 vss.n2270 vss.n2209 0.0605
R3609 vss.n2278 vss.n2209 0.0605
R3610 vss.n2223 vss.n2222 0.0605
R3611 vss.n2226 vss.n2223 0.0605
R3612 vss.n2226 vss.n2218 0.0605
R3613 vss.n2232 vss.n2218 0.0605
R3614 vss.n2233 vss.n2232 0.0605
R3615 vss.n2236 vss.n2233 0.0605
R3616 vss.n2236 vss.n2216 0.0605
R3617 vss.n2242 vss.n2216 0.0605
R3618 vss.n2243 vss.n2242 0.0605
R3619 vss.n2246 vss.n2243 0.0605
R3620 vss.n2246 vss.n2214 0.0605
R3621 vss.n2253 vss.n2214 0.0605
R3622 vss.n2254 vss.n2253 0.0605
R3623 vss.n2257 vss.n2254 0.0605
R3624 vss.n2257 vss.n2212 0.0605
R3625 vss.n2263 vss.n2212 0.0605
R3626 vss.n2264 vss.n2263 0.0605
R3627 vss.n2267 vss.n2264 0.0605
R3628 vss.n2267 vss.n2210 0.0605
R3629 vss.n2273 vss.n2210 0.0605
R3630 vss.n2274 vss.n2273 0.0605
R3631 vss.n2277 vss.n2274 0.0605
R3632 vss.n2277 vss.n2208 0.0605
R3633 vss.n2221 vss.n2194 0.0605
R3634 vss.n2225 vss.n2224 0.0605
R3635 vss.n2231 vss.n2230 0.0605
R3636 vss.n2235 vss.n2234 0.0605
R3637 vss.n2241 vss.n2240 0.0605
R3638 vss.n2245 vss.n2244 0.0605
R3639 vss.n2252 vss.n2251 0.0605
R3640 vss.n2256 vss.n2255 0.0605
R3641 vss.n2262 vss.n2261 0.0605
R3642 vss.n2266 vss.n2265 0.0605
R3643 vss.n2272 vss.n2271 0.0605
R3644 vss.n2276 vss.n2275 0.0605
R3645 vss.n2280 vss.n2207 0.0605
R3646 vss.n2139 vss.n2131 0.0605
R3647 vss.n2140 vss.n2139 0.0605
R3648 vss.n2141 vss.n2140 0.0605
R3649 vss.n2141 vss.n2129 0.0605
R3650 vss.n2149 vss.n2129 0.0605
R3651 vss.n2150 vss.n2149 0.0605
R3652 vss.n2151 vss.n2150 0.0605
R3653 vss.n2151 vss.n2127 0.0605
R3654 vss.n2159 vss.n2127 0.0605
R3655 vss.n2160 vss.n2159 0.0605
R3656 vss.n2162 vss.n2125 0.0605
R3657 vss.n2170 vss.n2125 0.0605
R3658 vss.n2171 vss.n2170 0.0605
R3659 vss.n2172 vss.n2171 0.0605
R3660 vss.n2172 vss.n2123 0.0605
R3661 vss.n2180 vss.n2123 0.0605
R3662 vss.n2181 vss.n2180 0.0605
R3663 vss.n2182 vss.n2181 0.0605
R3664 vss.n2182 vss.n2121 0.0605
R3665 vss.n2190 vss.n2121 0.0605
R3666 vss.n2135 vss.n2134 0.0605
R3667 vss.n2138 vss.n2135 0.0605
R3668 vss.n2138 vss.n2130 0.0605
R3669 vss.n2144 vss.n2130 0.0605
R3670 vss.n2145 vss.n2144 0.0605
R3671 vss.n2148 vss.n2145 0.0605
R3672 vss.n2148 vss.n2128 0.0605
R3673 vss.n2154 vss.n2128 0.0605
R3674 vss.n2155 vss.n2154 0.0605
R3675 vss.n2158 vss.n2155 0.0605
R3676 vss.n2158 vss.n2126 0.0605
R3677 vss.n2165 vss.n2126 0.0605
R3678 vss.n2166 vss.n2165 0.0605
R3679 vss.n2169 vss.n2166 0.0605
R3680 vss.n2169 vss.n2124 0.0605
R3681 vss.n2175 vss.n2124 0.0605
R3682 vss.n2176 vss.n2175 0.0605
R3683 vss.n2179 vss.n2176 0.0605
R3684 vss.n2179 vss.n2122 0.0605
R3685 vss.n2185 vss.n2122 0.0605
R3686 vss.n2186 vss.n2185 0.0605
R3687 vss.n2189 vss.n2186 0.0605
R3688 vss.n2189 vss.n2120 0.0605
R3689 vss.n2133 vss.n2106 0.0605
R3690 vss.n2137 vss.n2136 0.0605
R3691 vss.n2143 vss.n2142 0.0605
R3692 vss.n2147 vss.n2146 0.0605
R3693 vss.n2153 vss.n2152 0.0605
R3694 vss.n2157 vss.n2156 0.0605
R3695 vss.n2164 vss.n2163 0.0605
R3696 vss.n2168 vss.n2167 0.0605
R3697 vss.n2174 vss.n2173 0.0605
R3698 vss.n2178 vss.n2177 0.0605
R3699 vss.n2184 vss.n2183 0.0605
R3700 vss.n2188 vss.n2187 0.0605
R3701 vss.n2192 vss.n2119 0.0605
R3702 vss.n2051 vss.n2043 0.0605
R3703 vss.n2052 vss.n2051 0.0605
R3704 vss.n2053 vss.n2052 0.0605
R3705 vss.n2053 vss.n2041 0.0605
R3706 vss.n2061 vss.n2041 0.0605
R3707 vss.n2062 vss.n2061 0.0605
R3708 vss.n2063 vss.n2062 0.0605
R3709 vss.n2063 vss.n2039 0.0605
R3710 vss.n2071 vss.n2039 0.0605
R3711 vss.n2072 vss.n2071 0.0605
R3712 vss.n2074 vss.n2037 0.0605
R3713 vss.n2082 vss.n2037 0.0605
R3714 vss.n2083 vss.n2082 0.0605
R3715 vss.n2084 vss.n2083 0.0605
R3716 vss.n2084 vss.n2035 0.0605
R3717 vss.n2092 vss.n2035 0.0605
R3718 vss.n2093 vss.n2092 0.0605
R3719 vss.n2094 vss.n2093 0.0605
R3720 vss.n2094 vss.n2033 0.0605
R3721 vss.n2102 vss.n2033 0.0605
R3722 vss.n2047 vss.n2046 0.0605
R3723 vss.n2050 vss.n2047 0.0605
R3724 vss.n2050 vss.n2042 0.0605
R3725 vss.n2056 vss.n2042 0.0605
R3726 vss.n2057 vss.n2056 0.0605
R3727 vss.n2060 vss.n2057 0.0605
R3728 vss.n2060 vss.n2040 0.0605
R3729 vss.n2066 vss.n2040 0.0605
R3730 vss.n2067 vss.n2066 0.0605
R3731 vss.n2070 vss.n2067 0.0605
R3732 vss.n2070 vss.n2038 0.0605
R3733 vss.n2077 vss.n2038 0.0605
R3734 vss.n2078 vss.n2077 0.0605
R3735 vss.n2081 vss.n2078 0.0605
R3736 vss.n2081 vss.n2036 0.0605
R3737 vss.n2087 vss.n2036 0.0605
R3738 vss.n2088 vss.n2087 0.0605
R3739 vss.n2091 vss.n2088 0.0605
R3740 vss.n2091 vss.n2034 0.0605
R3741 vss.n2097 vss.n2034 0.0605
R3742 vss.n2098 vss.n2097 0.0605
R3743 vss.n2101 vss.n2098 0.0605
R3744 vss.n2101 vss.n2032 0.0605
R3745 vss.n2045 vss.n2018 0.0605
R3746 vss.n2049 vss.n2048 0.0605
R3747 vss.n2055 vss.n2054 0.0605
R3748 vss.n2059 vss.n2058 0.0605
R3749 vss.n2065 vss.n2064 0.0605
R3750 vss.n2069 vss.n2068 0.0605
R3751 vss.n2076 vss.n2075 0.0605
R3752 vss.n2080 vss.n2079 0.0605
R3753 vss.n2086 vss.n2085 0.0605
R3754 vss.n2090 vss.n2089 0.0605
R3755 vss.n2096 vss.n2095 0.0605
R3756 vss.n2100 vss.n2099 0.0605
R3757 vss.n2104 vss.n2031 0.0605
R3758 vss.n1963 vss.n1955 0.0605
R3759 vss.n1964 vss.n1963 0.0605
R3760 vss.n1965 vss.n1964 0.0605
R3761 vss.n1965 vss.n1953 0.0605
R3762 vss.n1973 vss.n1953 0.0605
R3763 vss.n1974 vss.n1973 0.0605
R3764 vss.n1975 vss.n1974 0.0605
R3765 vss.n1975 vss.n1951 0.0605
R3766 vss.n1983 vss.n1951 0.0605
R3767 vss.n1984 vss.n1983 0.0605
R3768 vss.n1986 vss.n1949 0.0605
R3769 vss.n1994 vss.n1949 0.0605
R3770 vss.n1995 vss.n1994 0.0605
R3771 vss.n1996 vss.n1995 0.0605
R3772 vss.n1996 vss.n1947 0.0605
R3773 vss.n2004 vss.n1947 0.0605
R3774 vss.n2005 vss.n2004 0.0605
R3775 vss.n2006 vss.n2005 0.0605
R3776 vss.n2006 vss.n1945 0.0605
R3777 vss.n2014 vss.n1945 0.0605
R3778 vss.n1959 vss.n1958 0.0605
R3779 vss.n1962 vss.n1959 0.0605
R3780 vss.n1962 vss.n1954 0.0605
R3781 vss.n1968 vss.n1954 0.0605
R3782 vss.n1969 vss.n1968 0.0605
R3783 vss.n1972 vss.n1969 0.0605
R3784 vss.n1972 vss.n1952 0.0605
R3785 vss.n1978 vss.n1952 0.0605
R3786 vss.n1979 vss.n1978 0.0605
R3787 vss.n1982 vss.n1979 0.0605
R3788 vss.n1982 vss.n1950 0.0605
R3789 vss.n1989 vss.n1950 0.0605
R3790 vss.n1990 vss.n1989 0.0605
R3791 vss.n1993 vss.n1990 0.0605
R3792 vss.n1993 vss.n1948 0.0605
R3793 vss.n1999 vss.n1948 0.0605
R3794 vss.n2000 vss.n1999 0.0605
R3795 vss.n2003 vss.n2000 0.0605
R3796 vss.n2003 vss.n1946 0.0605
R3797 vss.n2009 vss.n1946 0.0605
R3798 vss.n2010 vss.n2009 0.0605
R3799 vss.n2013 vss.n2010 0.0605
R3800 vss.n2013 vss.n1944 0.0605
R3801 vss.n1957 vss.n1930 0.0605
R3802 vss.n1961 vss.n1960 0.0605
R3803 vss.n1967 vss.n1966 0.0605
R3804 vss.n1971 vss.n1970 0.0605
R3805 vss.n1977 vss.n1976 0.0605
R3806 vss.n1981 vss.n1980 0.0605
R3807 vss.n1988 vss.n1987 0.0605
R3808 vss.n1992 vss.n1991 0.0605
R3809 vss.n1998 vss.n1997 0.0605
R3810 vss.n2002 vss.n2001 0.0605
R3811 vss.n2008 vss.n2007 0.0605
R3812 vss.n2012 vss.n2011 0.0605
R3813 vss.n2016 vss.n1943 0.0605
R3814 vss.n1875 vss.n1867 0.0605
R3815 vss.n1876 vss.n1875 0.0605
R3816 vss.n1877 vss.n1876 0.0605
R3817 vss.n1877 vss.n1865 0.0605
R3818 vss.n1885 vss.n1865 0.0605
R3819 vss.n1886 vss.n1885 0.0605
R3820 vss.n1887 vss.n1886 0.0605
R3821 vss.n1887 vss.n1863 0.0605
R3822 vss.n1895 vss.n1863 0.0605
R3823 vss.n1896 vss.n1895 0.0605
R3824 vss.n1898 vss.n1861 0.0605
R3825 vss.n1906 vss.n1861 0.0605
R3826 vss.n1907 vss.n1906 0.0605
R3827 vss.n1908 vss.n1907 0.0605
R3828 vss.n1908 vss.n1859 0.0605
R3829 vss.n1916 vss.n1859 0.0605
R3830 vss.n1917 vss.n1916 0.0605
R3831 vss.n1918 vss.n1917 0.0605
R3832 vss.n1918 vss.n1857 0.0605
R3833 vss.n1926 vss.n1857 0.0605
R3834 vss.n1871 vss.n1870 0.0605
R3835 vss.n1874 vss.n1871 0.0605
R3836 vss.n1874 vss.n1866 0.0605
R3837 vss.n1880 vss.n1866 0.0605
R3838 vss.n1881 vss.n1880 0.0605
R3839 vss.n1884 vss.n1881 0.0605
R3840 vss.n1884 vss.n1864 0.0605
R3841 vss.n1890 vss.n1864 0.0605
R3842 vss.n1891 vss.n1890 0.0605
R3843 vss.n1894 vss.n1891 0.0605
R3844 vss.n1894 vss.n1862 0.0605
R3845 vss.n1901 vss.n1862 0.0605
R3846 vss.n1902 vss.n1901 0.0605
R3847 vss.n1905 vss.n1902 0.0605
R3848 vss.n1905 vss.n1860 0.0605
R3849 vss.n1911 vss.n1860 0.0605
R3850 vss.n1912 vss.n1911 0.0605
R3851 vss.n1915 vss.n1912 0.0605
R3852 vss.n1915 vss.n1858 0.0605
R3853 vss.n1921 vss.n1858 0.0605
R3854 vss.n1922 vss.n1921 0.0605
R3855 vss.n1925 vss.n1922 0.0605
R3856 vss.n1925 vss.n1856 0.0605
R3857 vss.n1869 vss.n1842 0.0605
R3858 vss.n1873 vss.n1872 0.0605
R3859 vss.n1879 vss.n1878 0.0605
R3860 vss.n1883 vss.n1882 0.0605
R3861 vss.n1889 vss.n1888 0.0605
R3862 vss.n1893 vss.n1892 0.0605
R3863 vss.n1900 vss.n1899 0.0605
R3864 vss.n1904 vss.n1903 0.0605
R3865 vss.n1910 vss.n1909 0.0605
R3866 vss.n1914 vss.n1913 0.0605
R3867 vss.n1920 vss.n1919 0.0605
R3868 vss.n1924 vss.n1923 0.0605
R3869 vss.n1928 vss.n1855 0.0605
R3870 vss.n1787 vss.n1779 0.0605
R3871 vss.n1788 vss.n1787 0.0605
R3872 vss.n1789 vss.n1788 0.0605
R3873 vss.n1789 vss.n1777 0.0605
R3874 vss.n1797 vss.n1777 0.0605
R3875 vss.n1798 vss.n1797 0.0605
R3876 vss.n1799 vss.n1798 0.0605
R3877 vss.n1799 vss.n1775 0.0605
R3878 vss.n1807 vss.n1775 0.0605
R3879 vss.n1808 vss.n1807 0.0605
R3880 vss.n1810 vss.n1773 0.0605
R3881 vss.n1818 vss.n1773 0.0605
R3882 vss.n1819 vss.n1818 0.0605
R3883 vss.n1820 vss.n1819 0.0605
R3884 vss.n1820 vss.n1771 0.0605
R3885 vss.n1828 vss.n1771 0.0605
R3886 vss.n1829 vss.n1828 0.0605
R3887 vss.n1830 vss.n1829 0.0605
R3888 vss.n1830 vss.n1769 0.0605
R3889 vss.n1838 vss.n1769 0.0605
R3890 vss.n1783 vss.n1782 0.0605
R3891 vss.n1786 vss.n1783 0.0605
R3892 vss.n1786 vss.n1778 0.0605
R3893 vss.n1792 vss.n1778 0.0605
R3894 vss.n1793 vss.n1792 0.0605
R3895 vss.n1796 vss.n1793 0.0605
R3896 vss.n1796 vss.n1776 0.0605
R3897 vss.n1802 vss.n1776 0.0605
R3898 vss.n1803 vss.n1802 0.0605
R3899 vss.n1806 vss.n1803 0.0605
R3900 vss.n1806 vss.n1774 0.0605
R3901 vss.n1813 vss.n1774 0.0605
R3902 vss.n1814 vss.n1813 0.0605
R3903 vss.n1817 vss.n1814 0.0605
R3904 vss.n1817 vss.n1772 0.0605
R3905 vss.n1823 vss.n1772 0.0605
R3906 vss.n1824 vss.n1823 0.0605
R3907 vss.n1827 vss.n1824 0.0605
R3908 vss.n1827 vss.n1770 0.0605
R3909 vss.n1833 vss.n1770 0.0605
R3910 vss.n1834 vss.n1833 0.0605
R3911 vss.n1837 vss.n1834 0.0605
R3912 vss.n1837 vss.n1768 0.0605
R3913 vss.n1781 vss.n1754 0.0605
R3914 vss.n1785 vss.n1784 0.0605
R3915 vss.n1791 vss.n1790 0.0605
R3916 vss.n1795 vss.n1794 0.0605
R3917 vss.n1801 vss.n1800 0.0605
R3918 vss.n1805 vss.n1804 0.0605
R3919 vss.n1812 vss.n1811 0.0605
R3920 vss.n1816 vss.n1815 0.0605
R3921 vss.n1822 vss.n1821 0.0605
R3922 vss.n1826 vss.n1825 0.0605
R3923 vss.n1832 vss.n1831 0.0605
R3924 vss.n1836 vss.n1835 0.0605
R3925 vss.n1840 vss.n1767 0.0605
R3926 vss.n1699 vss.n1691 0.0605
R3927 vss.n1700 vss.n1699 0.0605
R3928 vss.n1701 vss.n1700 0.0605
R3929 vss.n1701 vss.n1689 0.0605
R3930 vss.n1709 vss.n1689 0.0605
R3931 vss.n1710 vss.n1709 0.0605
R3932 vss.n1711 vss.n1710 0.0605
R3933 vss.n1711 vss.n1687 0.0605
R3934 vss.n1719 vss.n1687 0.0605
R3935 vss.n1720 vss.n1719 0.0605
R3936 vss.n1722 vss.n1685 0.0605
R3937 vss.n1730 vss.n1685 0.0605
R3938 vss.n1731 vss.n1730 0.0605
R3939 vss.n1732 vss.n1731 0.0605
R3940 vss.n1732 vss.n1683 0.0605
R3941 vss.n1740 vss.n1683 0.0605
R3942 vss.n1741 vss.n1740 0.0605
R3943 vss.n1742 vss.n1741 0.0605
R3944 vss.n1742 vss.n1681 0.0605
R3945 vss.n1750 vss.n1681 0.0605
R3946 vss.n1695 vss.n1694 0.0605
R3947 vss.n1698 vss.n1695 0.0605
R3948 vss.n1698 vss.n1690 0.0605
R3949 vss.n1704 vss.n1690 0.0605
R3950 vss.n1705 vss.n1704 0.0605
R3951 vss.n1708 vss.n1705 0.0605
R3952 vss.n1708 vss.n1688 0.0605
R3953 vss.n1714 vss.n1688 0.0605
R3954 vss.n1715 vss.n1714 0.0605
R3955 vss.n1718 vss.n1715 0.0605
R3956 vss.n1718 vss.n1686 0.0605
R3957 vss.n1725 vss.n1686 0.0605
R3958 vss.n1726 vss.n1725 0.0605
R3959 vss.n1729 vss.n1726 0.0605
R3960 vss.n1729 vss.n1684 0.0605
R3961 vss.n1735 vss.n1684 0.0605
R3962 vss.n1736 vss.n1735 0.0605
R3963 vss.n1739 vss.n1736 0.0605
R3964 vss.n1739 vss.n1682 0.0605
R3965 vss.n1745 vss.n1682 0.0605
R3966 vss.n1746 vss.n1745 0.0605
R3967 vss.n1749 vss.n1746 0.0605
R3968 vss.n1749 vss.n1680 0.0605
R3969 vss.n1693 vss.n1666 0.0605
R3970 vss.n1697 vss.n1696 0.0605
R3971 vss.n1703 vss.n1702 0.0605
R3972 vss.n1707 vss.n1706 0.0605
R3973 vss.n1713 vss.n1712 0.0605
R3974 vss.n1717 vss.n1716 0.0605
R3975 vss.n1724 vss.n1723 0.0605
R3976 vss.n1728 vss.n1727 0.0605
R3977 vss.n1734 vss.n1733 0.0605
R3978 vss.n1738 vss.n1737 0.0605
R3979 vss.n1744 vss.n1743 0.0605
R3980 vss.n1748 vss.n1747 0.0605
R3981 vss.n1752 vss.n1679 0.0605
R3982 vss.n1611 vss.n1603 0.0605
R3983 vss.n1612 vss.n1611 0.0605
R3984 vss.n1613 vss.n1612 0.0605
R3985 vss.n1613 vss.n1601 0.0605
R3986 vss.n1621 vss.n1601 0.0605
R3987 vss.n1622 vss.n1621 0.0605
R3988 vss.n1623 vss.n1622 0.0605
R3989 vss.n1623 vss.n1599 0.0605
R3990 vss.n1631 vss.n1599 0.0605
R3991 vss.n1632 vss.n1631 0.0605
R3992 vss.n1634 vss.n1597 0.0605
R3993 vss.n1642 vss.n1597 0.0605
R3994 vss.n1643 vss.n1642 0.0605
R3995 vss.n1644 vss.n1643 0.0605
R3996 vss.n1644 vss.n1595 0.0605
R3997 vss.n1652 vss.n1595 0.0605
R3998 vss.n1653 vss.n1652 0.0605
R3999 vss.n1654 vss.n1653 0.0605
R4000 vss.n1654 vss.n1593 0.0605
R4001 vss.n1662 vss.n1593 0.0605
R4002 vss.n1607 vss.n1606 0.0605
R4003 vss.n1610 vss.n1607 0.0605
R4004 vss.n1610 vss.n1602 0.0605
R4005 vss.n1616 vss.n1602 0.0605
R4006 vss.n1617 vss.n1616 0.0605
R4007 vss.n1620 vss.n1617 0.0605
R4008 vss.n1620 vss.n1600 0.0605
R4009 vss.n1626 vss.n1600 0.0605
R4010 vss.n1627 vss.n1626 0.0605
R4011 vss.n1630 vss.n1627 0.0605
R4012 vss.n1630 vss.n1598 0.0605
R4013 vss.n1637 vss.n1598 0.0605
R4014 vss.n1638 vss.n1637 0.0605
R4015 vss.n1641 vss.n1638 0.0605
R4016 vss.n1641 vss.n1596 0.0605
R4017 vss.n1647 vss.n1596 0.0605
R4018 vss.n1648 vss.n1647 0.0605
R4019 vss.n1651 vss.n1648 0.0605
R4020 vss.n1651 vss.n1594 0.0605
R4021 vss.n1657 vss.n1594 0.0605
R4022 vss.n1658 vss.n1657 0.0605
R4023 vss.n1661 vss.n1658 0.0605
R4024 vss.n1661 vss.n1592 0.0605
R4025 vss.n1605 vss.n1578 0.0605
R4026 vss.n1609 vss.n1608 0.0605
R4027 vss.n1615 vss.n1614 0.0605
R4028 vss.n1619 vss.n1618 0.0605
R4029 vss.n1625 vss.n1624 0.0605
R4030 vss.n1629 vss.n1628 0.0605
R4031 vss.n1636 vss.n1635 0.0605
R4032 vss.n1640 vss.n1639 0.0605
R4033 vss.n1646 vss.n1645 0.0605
R4034 vss.n1650 vss.n1649 0.0605
R4035 vss.n1656 vss.n1655 0.0605
R4036 vss.n1660 vss.n1659 0.0605
R4037 vss.n1664 vss.n1591 0.0605
R4038 vss.n2445 vss.n2437 0.0605
R4039 vss.n2446 vss.n2445 0.0605
R4040 vss.n2447 vss.n2446 0.0605
R4041 vss.n2447 vss.n2435 0.0605
R4042 vss.n2455 vss.n2435 0.0605
R4043 vss.n2456 vss.n2455 0.0605
R4044 vss.n2457 vss.n2456 0.0605
R4045 vss.n2457 vss.n2433 0.0605
R4046 vss.n2465 vss.n2433 0.0605
R4047 vss.n2466 vss.n2465 0.0605
R4048 vss.n2468 vss.n2431 0.0605
R4049 vss.n2476 vss.n2431 0.0605
R4050 vss.n2477 vss.n2476 0.0605
R4051 vss.n2478 vss.n2477 0.0605
R4052 vss.n2478 vss.n2429 0.0605
R4053 vss.n2486 vss.n2429 0.0605
R4054 vss.n2487 vss.n2486 0.0605
R4055 vss.n2488 vss.n2487 0.0605
R4056 vss.n2488 vss.n2427 0.0605
R4057 vss.n2496 vss.n2427 0.0605
R4058 vss.n2441 vss.n2440 0.0605
R4059 vss.n2444 vss.n2441 0.0605
R4060 vss.n2444 vss.n2436 0.0605
R4061 vss.n2450 vss.n2436 0.0605
R4062 vss.n2451 vss.n2450 0.0605
R4063 vss.n2454 vss.n2451 0.0605
R4064 vss.n2454 vss.n2434 0.0605
R4065 vss.n2460 vss.n2434 0.0605
R4066 vss.n2461 vss.n2460 0.0605
R4067 vss.n2464 vss.n2461 0.0605
R4068 vss.n2464 vss.n2432 0.0605
R4069 vss.n2471 vss.n2432 0.0605
R4070 vss.n2472 vss.n2471 0.0605
R4071 vss.n2475 vss.n2472 0.0605
R4072 vss.n2475 vss.n2430 0.0605
R4073 vss.n2481 vss.n2430 0.0605
R4074 vss.n2482 vss.n2481 0.0605
R4075 vss.n2485 vss.n2482 0.0605
R4076 vss.n2485 vss.n2428 0.0605
R4077 vss.n2491 vss.n2428 0.0605
R4078 vss.n2492 vss.n2491 0.0605
R4079 vss.n2495 vss.n2492 0.0605
R4080 vss.n2495 vss.n2426 0.0605
R4081 vss.n2439 vss.n2412 0.0605
R4082 vss.n2443 vss.n2442 0.0605
R4083 vss.n2449 vss.n2448 0.0605
R4084 vss.n2453 vss.n2452 0.0605
R4085 vss.n2459 vss.n2458 0.0605
R4086 vss.n2463 vss.n2462 0.0605
R4087 vss.n2470 vss.n2469 0.0605
R4088 vss.n2474 vss.n2473 0.0605
R4089 vss.n2480 vss.n2479 0.0605
R4090 vss.n2484 vss.n2483 0.0605
R4091 vss.n2490 vss.n2489 0.0605
R4092 vss.n2494 vss.n2493 0.0605
R4093 vss.n2498 vss.n2425 0.0605
R4094 vss.n2357 vss.n2349 0.0605
R4095 vss.n2358 vss.n2357 0.0605
R4096 vss.n2359 vss.n2358 0.0605
R4097 vss.n2359 vss.n2347 0.0605
R4098 vss.n2367 vss.n2347 0.0605
R4099 vss.n2368 vss.n2367 0.0605
R4100 vss.n2369 vss.n2368 0.0605
R4101 vss.n2369 vss.n2345 0.0605
R4102 vss.n2377 vss.n2345 0.0605
R4103 vss.n2378 vss.n2377 0.0605
R4104 vss.n2380 vss.n2343 0.0605
R4105 vss.n2388 vss.n2343 0.0605
R4106 vss.n2389 vss.n2388 0.0605
R4107 vss.n2390 vss.n2389 0.0605
R4108 vss.n2390 vss.n2341 0.0605
R4109 vss.n2398 vss.n2341 0.0605
R4110 vss.n2399 vss.n2398 0.0605
R4111 vss.n2400 vss.n2399 0.0605
R4112 vss.n2400 vss.n2339 0.0605
R4113 vss.n2408 vss.n2339 0.0605
R4114 vss.n2353 vss.n2352 0.0605
R4115 vss.n2356 vss.n2353 0.0605
R4116 vss.n2356 vss.n2348 0.0605
R4117 vss.n2362 vss.n2348 0.0605
R4118 vss.n2363 vss.n2362 0.0605
R4119 vss.n2366 vss.n2363 0.0605
R4120 vss.n2366 vss.n2346 0.0605
R4121 vss.n2372 vss.n2346 0.0605
R4122 vss.n2373 vss.n2372 0.0605
R4123 vss.n2376 vss.n2373 0.0605
R4124 vss.n2376 vss.n2344 0.0605
R4125 vss.n2383 vss.n2344 0.0605
R4126 vss.n2384 vss.n2383 0.0605
R4127 vss.n2387 vss.n2384 0.0605
R4128 vss.n2387 vss.n2342 0.0605
R4129 vss.n2393 vss.n2342 0.0605
R4130 vss.n2394 vss.n2393 0.0605
R4131 vss.n2397 vss.n2394 0.0605
R4132 vss.n2397 vss.n2340 0.0605
R4133 vss.n2403 vss.n2340 0.0605
R4134 vss.n2404 vss.n2403 0.0605
R4135 vss.n2407 vss.n2404 0.0605
R4136 vss.n2407 vss.n2338 0.0605
R4137 vss.n2351 vss.n2324 0.0605
R4138 vss.n2355 vss.n2354 0.0605
R4139 vss.n2361 vss.n2360 0.0605
R4140 vss.n2365 vss.n2364 0.0605
R4141 vss.n2371 vss.n2370 0.0605
R4142 vss.n2375 vss.n2374 0.0605
R4143 vss.n2382 vss.n2381 0.0605
R4144 vss.n2386 vss.n2385 0.0605
R4145 vss.n2392 vss.n2391 0.0605
R4146 vss.n2396 vss.n2395 0.0605
R4147 vss.n2402 vss.n2401 0.0605
R4148 vss.n2406 vss.n2405 0.0605
R4149 vss.n2410 vss.n2337 0.0605
R4150 vss.n2803 vss.n2795 0.0605
R4151 vss.n2804 vss.n2803 0.0605
R4152 vss.n2805 vss.n2804 0.0605
R4153 vss.n2805 vss.n2793 0.0605
R4154 vss.n2813 vss.n2793 0.0605
R4155 vss.n2814 vss.n2813 0.0605
R4156 vss.n2815 vss.n2814 0.0605
R4157 vss.n2815 vss.n2791 0.0605
R4158 vss.n2823 vss.n2791 0.0605
R4159 vss.n2824 vss.n2823 0.0605
R4160 vss.n2826 vss.n2789 0.0605
R4161 vss.n2834 vss.n2789 0.0605
R4162 vss.n2835 vss.n2834 0.0605
R4163 vss.n2836 vss.n2835 0.0605
R4164 vss.n2836 vss.n2787 0.0605
R4165 vss.n2844 vss.n2787 0.0605
R4166 vss.n2845 vss.n2844 0.0605
R4167 vss.n2846 vss.n2845 0.0605
R4168 vss.n2846 vss.n2785 0.0605
R4169 vss.n2854 vss.n2785 0.0605
R4170 vss.n2799 vss.n2798 0.0605
R4171 vss.n2802 vss.n2799 0.0605
R4172 vss.n2802 vss.n2794 0.0605
R4173 vss.n2808 vss.n2794 0.0605
R4174 vss.n2809 vss.n2808 0.0605
R4175 vss.n2812 vss.n2809 0.0605
R4176 vss.n2812 vss.n2792 0.0605
R4177 vss.n2818 vss.n2792 0.0605
R4178 vss.n2819 vss.n2818 0.0605
R4179 vss.n2822 vss.n2819 0.0605
R4180 vss.n2822 vss.n2790 0.0605
R4181 vss.n2829 vss.n2790 0.0605
R4182 vss.n2830 vss.n2829 0.0605
R4183 vss.n2833 vss.n2830 0.0605
R4184 vss.n2833 vss.n2788 0.0605
R4185 vss.n2839 vss.n2788 0.0605
R4186 vss.n2840 vss.n2839 0.0605
R4187 vss.n2843 vss.n2840 0.0605
R4188 vss.n2843 vss.n2786 0.0605
R4189 vss.n2849 vss.n2786 0.0605
R4190 vss.n2850 vss.n2849 0.0605
R4191 vss.n2853 vss.n2850 0.0605
R4192 vss.n2853 vss.n2784 0.0605
R4193 vss.n2797 vss.n2770 0.0605
R4194 vss.n2801 vss.n2800 0.0605
R4195 vss.n2807 vss.n2806 0.0605
R4196 vss.n2811 vss.n2810 0.0605
R4197 vss.n2817 vss.n2816 0.0605
R4198 vss.n2821 vss.n2820 0.0605
R4199 vss.n2828 vss.n2827 0.0605
R4200 vss.n2832 vss.n2831 0.0605
R4201 vss.n2838 vss.n2837 0.0605
R4202 vss.n2842 vss.n2841 0.0605
R4203 vss.n2848 vss.n2847 0.0605
R4204 vss.n2852 vss.n2851 0.0605
R4205 vss.n2856 vss.n2783 0.0605
R4206 vss.n2715 vss.n2707 0.0605
R4207 vss.n2716 vss.n2715 0.0605
R4208 vss.n2717 vss.n2716 0.0605
R4209 vss.n2717 vss.n2705 0.0605
R4210 vss.n2725 vss.n2705 0.0605
R4211 vss.n2726 vss.n2725 0.0605
R4212 vss.n2727 vss.n2726 0.0605
R4213 vss.n2727 vss.n2703 0.0605
R4214 vss.n2735 vss.n2703 0.0605
R4215 vss.n2736 vss.n2735 0.0605
R4216 vss.n2738 vss.n2701 0.0605
R4217 vss.n2746 vss.n2701 0.0605
R4218 vss.n2747 vss.n2746 0.0605
R4219 vss.n2748 vss.n2747 0.0605
R4220 vss.n2748 vss.n2699 0.0605
R4221 vss.n2756 vss.n2699 0.0605
R4222 vss.n2757 vss.n2756 0.0605
R4223 vss.n2758 vss.n2757 0.0605
R4224 vss.n2758 vss.n2697 0.0605
R4225 vss.n2766 vss.n2697 0.0605
R4226 vss.n2711 vss.n2710 0.0605
R4227 vss.n2714 vss.n2711 0.0605
R4228 vss.n2714 vss.n2706 0.0605
R4229 vss.n2720 vss.n2706 0.0605
R4230 vss.n2721 vss.n2720 0.0605
R4231 vss.n2724 vss.n2721 0.0605
R4232 vss.n2724 vss.n2704 0.0605
R4233 vss.n2730 vss.n2704 0.0605
R4234 vss.n2731 vss.n2730 0.0605
R4235 vss.n2734 vss.n2731 0.0605
R4236 vss.n2734 vss.n2702 0.0605
R4237 vss.n2741 vss.n2702 0.0605
R4238 vss.n2742 vss.n2741 0.0605
R4239 vss.n2745 vss.n2742 0.0605
R4240 vss.n2745 vss.n2700 0.0605
R4241 vss.n2751 vss.n2700 0.0605
R4242 vss.n2752 vss.n2751 0.0605
R4243 vss.n2755 vss.n2752 0.0605
R4244 vss.n2755 vss.n2698 0.0605
R4245 vss.n2761 vss.n2698 0.0605
R4246 vss.n2762 vss.n2761 0.0605
R4247 vss.n2765 vss.n2762 0.0605
R4248 vss.n2765 vss.n2696 0.0605
R4249 vss.n2709 vss.n2682 0.0605
R4250 vss.n2713 vss.n2712 0.0605
R4251 vss.n2719 vss.n2718 0.0605
R4252 vss.n2723 vss.n2722 0.0605
R4253 vss.n2729 vss.n2728 0.0605
R4254 vss.n2733 vss.n2732 0.0605
R4255 vss.n2740 vss.n2739 0.0605
R4256 vss.n2744 vss.n2743 0.0605
R4257 vss.n2750 vss.n2749 0.0605
R4258 vss.n2754 vss.n2753 0.0605
R4259 vss.n2760 vss.n2759 0.0605
R4260 vss.n2764 vss.n2763 0.0605
R4261 vss.n2768 vss.n2695 0.0605
R4262 vss.n2627 vss.n2619 0.0605
R4263 vss.n2628 vss.n2627 0.0605
R4264 vss.n2629 vss.n2628 0.0605
R4265 vss.n2629 vss.n2617 0.0605
R4266 vss.n2637 vss.n2617 0.0605
R4267 vss.n2638 vss.n2637 0.0605
R4268 vss.n2639 vss.n2638 0.0605
R4269 vss.n2639 vss.n2615 0.0605
R4270 vss.n2647 vss.n2615 0.0605
R4271 vss.n2648 vss.n2647 0.0605
R4272 vss.n2650 vss.n2613 0.0605
R4273 vss.n2658 vss.n2613 0.0605
R4274 vss.n2659 vss.n2658 0.0605
R4275 vss.n2660 vss.n2659 0.0605
R4276 vss.n2660 vss.n2611 0.0605
R4277 vss.n2668 vss.n2611 0.0605
R4278 vss.n2669 vss.n2668 0.0605
R4279 vss.n2670 vss.n2669 0.0605
R4280 vss.n2670 vss.n2609 0.0605
R4281 vss.n2678 vss.n2609 0.0605
R4282 vss.n2623 vss.n2622 0.0605
R4283 vss.n2626 vss.n2623 0.0605
R4284 vss.n2626 vss.n2618 0.0605
R4285 vss.n2632 vss.n2618 0.0605
R4286 vss.n2633 vss.n2632 0.0605
R4287 vss.n2636 vss.n2633 0.0605
R4288 vss.n2636 vss.n2616 0.0605
R4289 vss.n2642 vss.n2616 0.0605
R4290 vss.n2643 vss.n2642 0.0605
R4291 vss.n2646 vss.n2643 0.0605
R4292 vss.n2646 vss.n2614 0.0605
R4293 vss.n2653 vss.n2614 0.0605
R4294 vss.n2654 vss.n2653 0.0605
R4295 vss.n2657 vss.n2654 0.0605
R4296 vss.n2657 vss.n2612 0.0605
R4297 vss.n2663 vss.n2612 0.0605
R4298 vss.n2664 vss.n2663 0.0605
R4299 vss.n2667 vss.n2664 0.0605
R4300 vss.n2667 vss.n2610 0.0605
R4301 vss.n2673 vss.n2610 0.0605
R4302 vss.n2674 vss.n2673 0.0605
R4303 vss.n2677 vss.n2674 0.0605
R4304 vss.n2677 vss.n2608 0.0605
R4305 vss.n2621 vss.n2594 0.0605
R4306 vss.n2625 vss.n2624 0.0605
R4307 vss.n2631 vss.n2630 0.0605
R4308 vss.n2635 vss.n2634 0.0605
R4309 vss.n2641 vss.n2640 0.0605
R4310 vss.n2645 vss.n2644 0.0605
R4311 vss.n2652 vss.n2651 0.0605
R4312 vss.n2656 vss.n2655 0.0605
R4313 vss.n2662 vss.n2661 0.0605
R4314 vss.n2666 vss.n2665 0.0605
R4315 vss.n2672 vss.n2671 0.0605
R4316 vss.n2676 vss.n2675 0.0605
R4317 vss.n2680 vss.n2607 0.0605
R4318 vss.n2539 vss.n2531 0.0605
R4319 vss.n2540 vss.n2539 0.0605
R4320 vss.n2541 vss.n2540 0.0605
R4321 vss.n2541 vss.n2529 0.0605
R4322 vss.n2549 vss.n2529 0.0605
R4323 vss.n2550 vss.n2549 0.0605
R4324 vss.n2551 vss.n2550 0.0605
R4325 vss.n2551 vss.n2527 0.0605
R4326 vss.n2559 vss.n2527 0.0605
R4327 vss.n2560 vss.n2559 0.0605
R4328 vss.n2562 vss.n2525 0.0605
R4329 vss.n2570 vss.n2525 0.0605
R4330 vss.n2571 vss.n2570 0.0605
R4331 vss.n2572 vss.n2571 0.0605
R4332 vss.n2572 vss.n2523 0.0605
R4333 vss.n2580 vss.n2523 0.0605
R4334 vss.n2581 vss.n2580 0.0605
R4335 vss.n2582 vss.n2581 0.0605
R4336 vss.n2582 vss.n2521 0.0605
R4337 vss.n2590 vss.n2521 0.0605
R4338 vss.n2535 vss.n2534 0.0605
R4339 vss.n2538 vss.n2535 0.0605
R4340 vss.n2538 vss.n2530 0.0605
R4341 vss.n2544 vss.n2530 0.0605
R4342 vss.n2545 vss.n2544 0.0605
R4343 vss.n2548 vss.n2545 0.0605
R4344 vss.n2548 vss.n2528 0.0605
R4345 vss.n2554 vss.n2528 0.0605
R4346 vss.n2555 vss.n2554 0.0605
R4347 vss.n2558 vss.n2555 0.0605
R4348 vss.n2558 vss.n2526 0.0605
R4349 vss.n2565 vss.n2526 0.0605
R4350 vss.n2566 vss.n2565 0.0605
R4351 vss.n2569 vss.n2566 0.0605
R4352 vss.n2569 vss.n2524 0.0605
R4353 vss.n2575 vss.n2524 0.0605
R4354 vss.n2576 vss.n2575 0.0605
R4355 vss.n2579 vss.n2576 0.0605
R4356 vss.n2579 vss.n2522 0.0605
R4357 vss.n2585 vss.n2522 0.0605
R4358 vss.n2586 vss.n2585 0.0605
R4359 vss.n2589 vss.n2586 0.0605
R4360 vss.n2589 vss.n2520 0.0605
R4361 vss.n2533 vss.n2506 0.0605
R4362 vss.n2537 vss.n2536 0.0605
R4363 vss.n2543 vss.n2542 0.0605
R4364 vss.n2547 vss.n2546 0.0605
R4365 vss.n2553 vss.n2552 0.0605
R4366 vss.n2557 vss.n2556 0.0605
R4367 vss.n2564 vss.n2563 0.0605
R4368 vss.n2568 vss.n2567 0.0605
R4369 vss.n2574 vss.n2573 0.0605
R4370 vss.n2578 vss.n2577 0.0605
R4371 vss.n2584 vss.n2583 0.0605
R4372 vss.n2588 vss.n2587 0.0605
R4373 vss.n2592 vss.n2519 0.0605
R4374 vss.n2918 vss.n2905 0.0605
R4375 vss.n2919 vss.n2918 0.0605
R4376 vss.n2920 vss.n2919 0.0605
R4377 vss.n2920 vss.n2899 0.0605
R4378 vss.n2928 vss.n2899 0.0605
R4379 vss.n2929 vss.n2928 0.0605
R4380 vss.n2930 vss.n2929 0.0605
R4381 vss.n2930 vss.n2893 0.0605
R4382 vss.n2938 vss.n2893 0.0605
R4383 vss.n2939 vss.n2938 0.0605
R4384 vss.n2941 vss.n2887 0.0605
R4385 vss.n2949 vss.n2887 0.0605
R4386 vss.n2950 vss.n2949 0.0605
R4387 vss.n2951 vss.n2950 0.0605
R4388 vss.n2951 vss.n2881 0.0605
R4389 vss.n2959 vss.n2881 0.0605
R4390 vss.n2960 vss.n2959 0.0605
R4391 vss.n2961 vss.n2960 0.0605
R4392 vss.n2961 vss.n2875 0.0605
R4393 vss.n2969 vss.n2875 0.0605
R4394 vss.n2911 vss.n2906 0.0605
R4395 vss.n2917 vss.n2906 0.0605
R4396 vss.n2917 vss.n2904 0.0605
R4397 vss.n2921 vss.n2904 0.0605
R4398 vss.n2921 vss.n2900 0.0605
R4399 vss.n2927 vss.n2900 0.0605
R4400 vss.n2927 vss.n2898 0.0605
R4401 vss.n2931 vss.n2898 0.0605
R4402 vss.n2931 vss.n2894 0.0605
R4403 vss.n2937 vss.n2894 0.0605
R4404 vss.n2937 vss.n2892 0.0605
R4405 vss.n2942 vss.n2892 0.0605
R4406 vss.n2942 vss.n2888 0.0605
R4407 vss.n2948 vss.n2888 0.0605
R4408 vss.n2948 vss.n2886 0.0605
R4409 vss.n2952 vss.n2886 0.0605
R4410 vss.n2952 vss.n2882 0.0605
R4411 vss.n2958 vss.n2882 0.0605
R4412 vss.n2958 vss.n2880 0.0605
R4413 vss.n2962 vss.n2880 0.0605
R4414 vss.n2962 vss.n2876 0.0605
R4415 vss.n2968 vss.n2876 0.0605
R4416 vss.n2968 vss.n2874 0.0605
R4417 vss.n2912 vss.n2909 0.0605
R4418 vss.n2912 vss.n2907 0.0605
R4419 vss.n2916 vss.n2907 0.0605
R4420 vss.n2916 vss.n2903 0.0605
R4421 vss.n2922 vss.n2903 0.0605
R4422 vss.n2922 vss.n2901 0.0605
R4423 vss.n2926 vss.n2901 0.0605
R4424 vss.n2926 vss.n2897 0.0605
R4425 vss.n2932 vss.n2897 0.0605
R4426 vss.n2932 vss.n2895 0.0605
R4427 vss.n2936 vss.n2895 0.0605
R4428 vss.n2936 vss.n2891 0.0605
R4429 vss.n2943 vss.n2891 0.0605
R4430 vss.n2943 vss.n2889 0.0605
R4431 vss.n2947 vss.n2889 0.0605
R4432 vss.n2947 vss.n2885 0.0605
R4433 vss.n2953 vss.n2885 0.0605
R4434 vss.n2953 vss.n2883 0.0605
R4435 vss.n2957 vss.n2883 0.0605
R4436 vss.n2957 vss.n2879 0.0605
R4437 vss.n2963 vss.n2879 0.0605
R4438 vss.n2963 vss.n2877 0.0605
R4439 vss.n2967 vss.n2877 0.0605
R4440 vss.n2967 vss.n2873 0.0605
R4441 vss.n2971 vss.n2873 0.0605
R4442 vss.n97 vss.n96 0.0605
R4443 vss.n97 vss.n91 0.0605
R4444 vss.n105 vss.n91 0.0605
R4445 vss.n108 vss.n107 0.0605
R4446 vss.n108 vss.n89 0.0605
R4447 vss.n116 vss.n89 0.0605
R4448 vss.n94 vss.n92 0.0605
R4449 vss.n100 vss.n92 0.0605
R4450 vss.n101 vss.n100 0.0605
R4451 vss.n104 vss.n101 0.0605
R4452 vss.n104 vss.n90 0.0605
R4453 vss.n111 vss.n90 0.0605
R4454 vss.n112 vss.n111 0.0605
R4455 vss.n115 vss.n112 0.0605
R4456 vss.n115 vss.n88 0.0605
R4457 vss.n93 vss.n81 0.0605
R4458 vss.n99 vss.n98 0.0605
R4459 vss.n103 vss.n102 0.0605
R4460 vss.n110 vss.n109 0.0605
R4461 vss.n114 vss.n113 0.0605
R4462 vss.n118 vss.n87 0.0605
R4463 vss.n75 vss.n72 0.0605
R4464 vss.n76 vss.n71 0.0605
R4465 vss.n132 vss.n129 0.0605
R4466 vss.n135 vss.n132 0.0605
R4467 vss.n135 vss.n126 0.0605
R4468 vss.n128 vss.n122 0.0605
R4469 vss.n134 vss.n133 0.0605
R4470 vss.n138 vss.n125 0.0605
R4471 vss.n2318 vss.n1555 0.05675
R4472 vss.n2282 vss.n1577 0.05675
R4473 vss.n2501 vss.n2500 0.05675
R4474 vss.n2860 vss.n2858 0.05675
R4475 vss.n3043 vss.n3041 0.05575
R4476 vss.n3031 vss.n3029 0.05575
R4477 vss.n3019 vss.n3017 0.05575
R4478 vss.n3003 vss.n61 0.05575
R4479 vss.t45 vss.t46 0.0452658
R4480 vss.t43 vss.t44 0.0452658
R4481 vss.t48 vss.t49 0.0452658
R4482 vss.t57 vss.t58 0.0452658
R4483 vss.n1497 vss.n1468 0.0308013
R4484 vss.n1503 vss.n1469 0.0308013
R4485 vss.n1507 vss.n1470 0.0308013
R4486 vss.n1513 vss.n1471 0.0308013
R4487 vss.n1517 vss.n1472 0.0308013
R4488 vss.n1524 vss.n1473 0.0308013
R4489 vss.n1528 vss.n1474 0.0308013
R4490 vss.n1534 vss.n1475 0.0308013
R4491 vss.n1538 vss.n1476 0.0308013
R4492 vss.n1544 vss.n1477 0.0308013
R4493 vss.n1548 vss.n1478 0.0308013
R4494 vss.n1480 vss.n1479 0.0308013
R4495 vss.n1409 vss.n1380 0.0308013
R4496 vss.n1415 vss.n1381 0.0308013
R4497 vss.n1419 vss.n1382 0.0308013
R4498 vss.n1425 vss.n1383 0.0308013
R4499 vss.n1429 vss.n1384 0.0308013
R4500 vss.n1436 vss.n1385 0.0308013
R4501 vss.n1440 vss.n1386 0.0308013
R4502 vss.n1446 vss.n1387 0.0308013
R4503 vss.n1450 vss.n1388 0.0308013
R4504 vss.n1456 vss.n1389 0.0308013
R4505 vss.n1460 vss.n1390 0.0308013
R4506 vss.n1392 vss.n1391 0.0308013
R4507 vss.n1321 vss.n1292 0.0308013
R4508 vss.n1327 vss.n1293 0.0308013
R4509 vss.n1331 vss.n1294 0.0308013
R4510 vss.n1337 vss.n1295 0.0308013
R4511 vss.n1341 vss.n1296 0.0308013
R4512 vss.n1348 vss.n1297 0.0308013
R4513 vss.n1352 vss.n1298 0.0308013
R4514 vss.n1358 vss.n1299 0.0308013
R4515 vss.n1362 vss.n1300 0.0308013
R4516 vss.n1368 vss.n1301 0.0308013
R4517 vss.n1372 vss.n1302 0.0308013
R4518 vss.n1304 vss.n1303 0.0308013
R4519 vss.n1233 vss.n1204 0.0308013
R4520 vss.n1239 vss.n1205 0.0308013
R4521 vss.n1243 vss.n1206 0.0308013
R4522 vss.n1249 vss.n1207 0.0308013
R4523 vss.n1253 vss.n1208 0.0308013
R4524 vss.n1260 vss.n1209 0.0308013
R4525 vss.n1264 vss.n1210 0.0308013
R4526 vss.n1270 vss.n1211 0.0308013
R4527 vss.n1274 vss.n1212 0.0308013
R4528 vss.n1280 vss.n1213 0.0308013
R4529 vss.n1284 vss.n1214 0.0308013
R4530 vss.n1216 vss.n1215 0.0308013
R4531 vss.n1145 vss.n1116 0.0308013
R4532 vss.n1151 vss.n1117 0.0308013
R4533 vss.n1155 vss.n1118 0.0308013
R4534 vss.n1161 vss.n1119 0.0308013
R4535 vss.n1165 vss.n1120 0.0308013
R4536 vss.n1172 vss.n1121 0.0308013
R4537 vss.n1176 vss.n1122 0.0308013
R4538 vss.n1182 vss.n1123 0.0308013
R4539 vss.n1186 vss.n1124 0.0308013
R4540 vss.n1192 vss.n1125 0.0308013
R4541 vss.n1196 vss.n1126 0.0308013
R4542 vss.n1128 vss.n1127 0.0308013
R4543 vss.n1057 vss.n1028 0.0308013
R4544 vss.n1063 vss.n1029 0.0308013
R4545 vss.n1067 vss.n1030 0.0308013
R4546 vss.n1073 vss.n1031 0.0308013
R4547 vss.n1077 vss.n1032 0.0308013
R4548 vss.n1084 vss.n1033 0.0308013
R4549 vss.n1088 vss.n1034 0.0308013
R4550 vss.n1094 vss.n1035 0.0308013
R4551 vss.n1098 vss.n1036 0.0308013
R4552 vss.n1104 vss.n1037 0.0308013
R4553 vss.n1108 vss.n1038 0.0308013
R4554 vss.n1040 vss.n1039 0.0308013
R4555 vss.n969 vss.n940 0.0308013
R4556 vss.n975 vss.n941 0.0308013
R4557 vss.n979 vss.n942 0.0308013
R4558 vss.n985 vss.n943 0.0308013
R4559 vss.n989 vss.n944 0.0308013
R4560 vss.n996 vss.n945 0.0308013
R4561 vss.n1000 vss.n946 0.0308013
R4562 vss.n1006 vss.n947 0.0308013
R4563 vss.n1010 vss.n948 0.0308013
R4564 vss.n1016 vss.n949 0.0308013
R4565 vss.n1020 vss.n950 0.0308013
R4566 vss.n952 vss.n951 0.0308013
R4567 vss.n881 vss.n852 0.0308013
R4568 vss.n887 vss.n853 0.0308013
R4569 vss.n891 vss.n854 0.0308013
R4570 vss.n897 vss.n855 0.0308013
R4571 vss.n901 vss.n856 0.0308013
R4572 vss.n908 vss.n857 0.0308013
R4573 vss.n912 vss.n858 0.0308013
R4574 vss.n918 vss.n859 0.0308013
R4575 vss.n922 vss.n860 0.0308013
R4576 vss.n928 vss.n861 0.0308013
R4577 vss.n932 vss.n862 0.0308013
R4578 vss.n864 vss.n863 0.0308013
R4579 vss.n793 vss.n764 0.0308013
R4580 vss.n799 vss.n765 0.0308013
R4581 vss.n803 vss.n766 0.0308013
R4582 vss.n809 vss.n767 0.0308013
R4583 vss.n813 vss.n768 0.0308013
R4584 vss.n820 vss.n769 0.0308013
R4585 vss.n824 vss.n770 0.0308013
R4586 vss.n830 vss.n771 0.0308013
R4587 vss.n834 vss.n772 0.0308013
R4588 vss.n840 vss.n773 0.0308013
R4589 vss.n844 vss.n774 0.0308013
R4590 vss.n776 vss.n775 0.0308013
R4591 vss.n705 vss.n676 0.0308013
R4592 vss.n711 vss.n677 0.0308013
R4593 vss.n715 vss.n678 0.0308013
R4594 vss.n721 vss.n679 0.0308013
R4595 vss.n725 vss.n680 0.0308013
R4596 vss.n732 vss.n681 0.0308013
R4597 vss.n736 vss.n682 0.0308013
R4598 vss.n742 vss.n683 0.0308013
R4599 vss.n746 vss.n684 0.0308013
R4600 vss.n752 vss.n685 0.0308013
R4601 vss.n756 vss.n686 0.0308013
R4602 vss.n688 vss.n687 0.0308013
R4603 vss.n617 vss.n588 0.0308013
R4604 vss.n623 vss.n589 0.0308013
R4605 vss.n627 vss.n590 0.0308013
R4606 vss.n633 vss.n591 0.0308013
R4607 vss.n637 vss.n592 0.0308013
R4608 vss.n644 vss.n593 0.0308013
R4609 vss.n648 vss.n594 0.0308013
R4610 vss.n654 vss.n595 0.0308013
R4611 vss.n658 vss.n596 0.0308013
R4612 vss.n664 vss.n597 0.0308013
R4613 vss.n668 vss.n598 0.0308013
R4614 vss.n600 vss.n599 0.0308013
R4615 vss.n529 vss.n500 0.0308013
R4616 vss.n535 vss.n501 0.0308013
R4617 vss.n539 vss.n502 0.0308013
R4618 vss.n545 vss.n503 0.0308013
R4619 vss.n549 vss.n504 0.0308013
R4620 vss.n556 vss.n505 0.0308013
R4621 vss.n560 vss.n506 0.0308013
R4622 vss.n566 vss.n507 0.0308013
R4623 vss.n570 vss.n508 0.0308013
R4624 vss.n576 vss.n509 0.0308013
R4625 vss.n580 vss.n510 0.0308013
R4626 vss.n512 vss.n511 0.0308013
R4627 vss.n441 vss.n412 0.0308013
R4628 vss.n447 vss.n413 0.0308013
R4629 vss.n451 vss.n414 0.0308013
R4630 vss.n457 vss.n415 0.0308013
R4631 vss.n461 vss.n416 0.0308013
R4632 vss.n468 vss.n417 0.0308013
R4633 vss.n472 vss.n418 0.0308013
R4634 vss.n478 vss.n419 0.0308013
R4635 vss.n482 vss.n420 0.0308013
R4636 vss.n488 vss.n421 0.0308013
R4637 vss.n492 vss.n422 0.0308013
R4638 vss.n424 vss.n423 0.0308013
R4639 vss.n353 vss.n324 0.0308013
R4640 vss.n359 vss.n325 0.0308013
R4641 vss.n363 vss.n326 0.0308013
R4642 vss.n369 vss.n327 0.0308013
R4643 vss.n373 vss.n328 0.0308013
R4644 vss.n380 vss.n329 0.0308013
R4645 vss.n384 vss.n330 0.0308013
R4646 vss.n390 vss.n331 0.0308013
R4647 vss.n394 vss.n332 0.0308013
R4648 vss.n400 vss.n333 0.0308013
R4649 vss.n404 vss.n334 0.0308013
R4650 vss.n336 vss.n335 0.0308013
R4651 vss.n265 vss.n236 0.0308013
R4652 vss.n271 vss.n237 0.0308013
R4653 vss.n275 vss.n238 0.0308013
R4654 vss.n281 vss.n239 0.0308013
R4655 vss.n285 vss.n240 0.0308013
R4656 vss.n292 vss.n241 0.0308013
R4657 vss.n296 vss.n242 0.0308013
R4658 vss.n302 vss.n243 0.0308013
R4659 vss.n306 vss.n244 0.0308013
R4660 vss.n312 vss.n245 0.0308013
R4661 vss.n316 vss.n246 0.0308013
R4662 vss.n248 vss.n247 0.0308013
R4663 vss.n177 vss.n148 0.0308013
R4664 vss.n183 vss.n149 0.0308013
R4665 vss.n187 vss.n150 0.0308013
R4666 vss.n193 vss.n151 0.0308013
R4667 vss.n197 vss.n152 0.0308013
R4668 vss.n204 vss.n153 0.0308013
R4669 vss.n208 vss.n154 0.0308013
R4670 vss.n214 vss.n155 0.0308013
R4671 vss.n218 vss.n156 0.0308013
R4672 vss.n224 vss.n157 0.0308013
R4673 vss.n228 vss.n158 0.0308013
R4674 vss.n160 vss.n159 0.0308013
R4675 vss.n229 vss.n159 0.0308013
R4676 vss.n225 vss.n158 0.0308013
R4677 vss.n219 vss.n157 0.0308013
R4678 vss.n215 vss.n156 0.0308013
R4679 vss.n209 vss.n155 0.0308013
R4680 vss.n205 vss.n154 0.0308013
R4681 vss.n198 vss.n153 0.0308013
R4682 vss.n194 vss.n152 0.0308013
R4683 vss.n188 vss.n151 0.0308013
R4684 vss.n184 vss.n150 0.0308013
R4685 vss.n178 vss.n149 0.0308013
R4686 vss.n174 vss.n148 0.0308013
R4687 vss.n317 vss.n247 0.0308013
R4688 vss.n313 vss.n246 0.0308013
R4689 vss.n307 vss.n245 0.0308013
R4690 vss.n303 vss.n244 0.0308013
R4691 vss.n297 vss.n243 0.0308013
R4692 vss.n293 vss.n242 0.0308013
R4693 vss.n286 vss.n241 0.0308013
R4694 vss.n282 vss.n240 0.0308013
R4695 vss.n276 vss.n239 0.0308013
R4696 vss.n272 vss.n238 0.0308013
R4697 vss.n266 vss.n237 0.0308013
R4698 vss.n262 vss.n236 0.0308013
R4699 vss.n405 vss.n335 0.0308013
R4700 vss.n401 vss.n334 0.0308013
R4701 vss.n395 vss.n333 0.0308013
R4702 vss.n391 vss.n332 0.0308013
R4703 vss.n385 vss.n331 0.0308013
R4704 vss.n381 vss.n330 0.0308013
R4705 vss.n374 vss.n329 0.0308013
R4706 vss.n370 vss.n328 0.0308013
R4707 vss.n364 vss.n327 0.0308013
R4708 vss.n360 vss.n326 0.0308013
R4709 vss.n354 vss.n325 0.0308013
R4710 vss.n350 vss.n324 0.0308013
R4711 vss.n493 vss.n423 0.0308013
R4712 vss.n489 vss.n422 0.0308013
R4713 vss.n483 vss.n421 0.0308013
R4714 vss.n479 vss.n420 0.0308013
R4715 vss.n473 vss.n419 0.0308013
R4716 vss.n469 vss.n418 0.0308013
R4717 vss.n462 vss.n417 0.0308013
R4718 vss.n458 vss.n416 0.0308013
R4719 vss.n452 vss.n415 0.0308013
R4720 vss.n448 vss.n414 0.0308013
R4721 vss.n442 vss.n413 0.0308013
R4722 vss.n438 vss.n412 0.0308013
R4723 vss.n581 vss.n511 0.0308013
R4724 vss.n577 vss.n510 0.0308013
R4725 vss.n571 vss.n509 0.0308013
R4726 vss.n567 vss.n508 0.0308013
R4727 vss.n561 vss.n507 0.0308013
R4728 vss.n557 vss.n506 0.0308013
R4729 vss.n550 vss.n505 0.0308013
R4730 vss.n546 vss.n504 0.0308013
R4731 vss.n540 vss.n503 0.0308013
R4732 vss.n536 vss.n502 0.0308013
R4733 vss.n530 vss.n501 0.0308013
R4734 vss.n526 vss.n500 0.0308013
R4735 vss.n669 vss.n599 0.0308013
R4736 vss.n665 vss.n598 0.0308013
R4737 vss.n659 vss.n597 0.0308013
R4738 vss.n655 vss.n596 0.0308013
R4739 vss.n649 vss.n595 0.0308013
R4740 vss.n645 vss.n594 0.0308013
R4741 vss.n638 vss.n593 0.0308013
R4742 vss.n634 vss.n592 0.0308013
R4743 vss.n628 vss.n591 0.0308013
R4744 vss.n624 vss.n590 0.0308013
R4745 vss.n618 vss.n589 0.0308013
R4746 vss.n614 vss.n588 0.0308013
R4747 vss.n757 vss.n687 0.0308013
R4748 vss.n753 vss.n686 0.0308013
R4749 vss.n747 vss.n685 0.0308013
R4750 vss.n743 vss.n684 0.0308013
R4751 vss.n737 vss.n683 0.0308013
R4752 vss.n733 vss.n682 0.0308013
R4753 vss.n726 vss.n681 0.0308013
R4754 vss.n722 vss.n680 0.0308013
R4755 vss.n716 vss.n679 0.0308013
R4756 vss.n712 vss.n678 0.0308013
R4757 vss.n706 vss.n677 0.0308013
R4758 vss.n702 vss.n676 0.0308013
R4759 vss.n845 vss.n775 0.0308013
R4760 vss.n841 vss.n774 0.0308013
R4761 vss.n835 vss.n773 0.0308013
R4762 vss.n831 vss.n772 0.0308013
R4763 vss.n825 vss.n771 0.0308013
R4764 vss.n821 vss.n770 0.0308013
R4765 vss.n814 vss.n769 0.0308013
R4766 vss.n810 vss.n768 0.0308013
R4767 vss.n804 vss.n767 0.0308013
R4768 vss.n800 vss.n766 0.0308013
R4769 vss.n794 vss.n765 0.0308013
R4770 vss.n790 vss.n764 0.0308013
R4771 vss.n933 vss.n863 0.0308013
R4772 vss.n929 vss.n862 0.0308013
R4773 vss.n923 vss.n861 0.0308013
R4774 vss.n919 vss.n860 0.0308013
R4775 vss.n913 vss.n859 0.0308013
R4776 vss.n909 vss.n858 0.0308013
R4777 vss.n902 vss.n857 0.0308013
R4778 vss.n898 vss.n856 0.0308013
R4779 vss.n892 vss.n855 0.0308013
R4780 vss.n888 vss.n854 0.0308013
R4781 vss.n882 vss.n853 0.0308013
R4782 vss.n878 vss.n852 0.0308013
R4783 vss.n1021 vss.n951 0.0308013
R4784 vss.n1017 vss.n950 0.0308013
R4785 vss.n1011 vss.n949 0.0308013
R4786 vss.n1007 vss.n948 0.0308013
R4787 vss.n1001 vss.n947 0.0308013
R4788 vss.n997 vss.n946 0.0308013
R4789 vss.n990 vss.n945 0.0308013
R4790 vss.n986 vss.n944 0.0308013
R4791 vss.n980 vss.n943 0.0308013
R4792 vss.n976 vss.n942 0.0308013
R4793 vss.n970 vss.n941 0.0308013
R4794 vss.n966 vss.n940 0.0308013
R4795 vss.n1109 vss.n1039 0.0308013
R4796 vss.n1105 vss.n1038 0.0308013
R4797 vss.n1099 vss.n1037 0.0308013
R4798 vss.n1095 vss.n1036 0.0308013
R4799 vss.n1089 vss.n1035 0.0308013
R4800 vss.n1085 vss.n1034 0.0308013
R4801 vss.n1078 vss.n1033 0.0308013
R4802 vss.n1074 vss.n1032 0.0308013
R4803 vss.n1068 vss.n1031 0.0308013
R4804 vss.n1064 vss.n1030 0.0308013
R4805 vss.n1058 vss.n1029 0.0308013
R4806 vss.n1054 vss.n1028 0.0308013
R4807 vss.n1197 vss.n1127 0.0308013
R4808 vss.n1193 vss.n1126 0.0308013
R4809 vss.n1187 vss.n1125 0.0308013
R4810 vss.n1183 vss.n1124 0.0308013
R4811 vss.n1177 vss.n1123 0.0308013
R4812 vss.n1173 vss.n1122 0.0308013
R4813 vss.n1166 vss.n1121 0.0308013
R4814 vss.n1162 vss.n1120 0.0308013
R4815 vss.n1156 vss.n1119 0.0308013
R4816 vss.n1152 vss.n1118 0.0308013
R4817 vss.n1146 vss.n1117 0.0308013
R4818 vss.n1142 vss.n1116 0.0308013
R4819 vss.n1285 vss.n1215 0.0308013
R4820 vss.n1281 vss.n1214 0.0308013
R4821 vss.n1275 vss.n1213 0.0308013
R4822 vss.n1271 vss.n1212 0.0308013
R4823 vss.n1265 vss.n1211 0.0308013
R4824 vss.n1261 vss.n1210 0.0308013
R4825 vss.n1254 vss.n1209 0.0308013
R4826 vss.n1250 vss.n1208 0.0308013
R4827 vss.n1244 vss.n1207 0.0308013
R4828 vss.n1240 vss.n1206 0.0308013
R4829 vss.n1234 vss.n1205 0.0308013
R4830 vss.n1230 vss.n1204 0.0308013
R4831 vss.n1373 vss.n1303 0.0308013
R4832 vss.n1369 vss.n1302 0.0308013
R4833 vss.n1363 vss.n1301 0.0308013
R4834 vss.n1359 vss.n1300 0.0308013
R4835 vss.n1353 vss.n1299 0.0308013
R4836 vss.n1349 vss.n1298 0.0308013
R4837 vss.n1342 vss.n1297 0.0308013
R4838 vss.n1338 vss.n1296 0.0308013
R4839 vss.n1332 vss.n1295 0.0308013
R4840 vss.n1328 vss.n1294 0.0308013
R4841 vss.n1322 vss.n1293 0.0308013
R4842 vss.n1318 vss.n1292 0.0308013
R4843 vss.n1461 vss.n1391 0.0308013
R4844 vss.n1457 vss.n1390 0.0308013
R4845 vss.n1451 vss.n1389 0.0308013
R4846 vss.n1447 vss.n1388 0.0308013
R4847 vss.n1441 vss.n1387 0.0308013
R4848 vss.n1437 vss.n1386 0.0308013
R4849 vss.n1430 vss.n1385 0.0308013
R4850 vss.n1426 vss.n1384 0.0308013
R4851 vss.n1420 vss.n1383 0.0308013
R4852 vss.n1416 vss.n1382 0.0308013
R4853 vss.n1410 vss.n1381 0.0308013
R4854 vss.n1406 vss.n1380 0.0308013
R4855 vss.n1549 vss.n1479 0.0308013
R4856 vss.n1545 vss.n1478 0.0308013
R4857 vss.n1539 vss.n1477 0.0308013
R4858 vss.n1535 vss.n1476 0.0308013
R4859 vss.n1529 vss.n1475 0.0308013
R4860 vss.n1525 vss.n1474 0.0308013
R4861 vss.n1518 vss.n1473 0.0308013
R4862 vss.n1514 vss.n1472 0.0308013
R4863 vss.n1508 vss.n1471 0.0308013
R4864 vss.n1504 vss.n1470 0.0308013
R4865 vss.n1498 vss.n1469 0.0308013
R4866 vss.n1494 vss.n1468 0.0308013
R4867 vss.n2224 vss.n2195 0.0308013
R4868 vss.n2230 vss.n2196 0.0308013
R4869 vss.n2234 vss.n2197 0.0308013
R4870 vss.n2240 vss.n2198 0.0308013
R4871 vss.n2244 vss.n2199 0.0308013
R4872 vss.n2251 vss.n2200 0.0308013
R4873 vss.n2255 vss.n2201 0.0308013
R4874 vss.n2261 vss.n2202 0.0308013
R4875 vss.n2265 vss.n2203 0.0308013
R4876 vss.n2271 vss.n2204 0.0308013
R4877 vss.n2275 vss.n2205 0.0308013
R4878 vss.n2207 vss.n2206 0.0308013
R4879 vss.n2136 vss.n2107 0.0308013
R4880 vss.n2142 vss.n2108 0.0308013
R4881 vss.n2146 vss.n2109 0.0308013
R4882 vss.n2152 vss.n2110 0.0308013
R4883 vss.n2156 vss.n2111 0.0308013
R4884 vss.n2163 vss.n2112 0.0308013
R4885 vss.n2167 vss.n2113 0.0308013
R4886 vss.n2173 vss.n2114 0.0308013
R4887 vss.n2177 vss.n2115 0.0308013
R4888 vss.n2183 vss.n2116 0.0308013
R4889 vss.n2187 vss.n2117 0.0308013
R4890 vss.n2119 vss.n2118 0.0308013
R4891 vss.n2048 vss.n2019 0.0308013
R4892 vss.n2054 vss.n2020 0.0308013
R4893 vss.n2058 vss.n2021 0.0308013
R4894 vss.n2064 vss.n2022 0.0308013
R4895 vss.n2068 vss.n2023 0.0308013
R4896 vss.n2075 vss.n2024 0.0308013
R4897 vss.n2079 vss.n2025 0.0308013
R4898 vss.n2085 vss.n2026 0.0308013
R4899 vss.n2089 vss.n2027 0.0308013
R4900 vss.n2095 vss.n2028 0.0308013
R4901 vss.n2099 vss.n2029 0.0308013
R4902 vss.n2031 vss.n2030 0.0308013
R4903 vss.n1960 vss.n1931 0.0308013
R4904 vss.n1966 vss.n1932 0.0308013
R4905 vss.n1970 vss.n1933 0.0308013
R4906 vss.n1976 vss.n1934 0.0308013
R4907 vss.n1980 vss.n1935 0.0308013
R4908 vss.n1987 vss.n1936 0.0308013
R4909 vss.n1991 vss.n1937 0.0308013
R4910 vss.n1997 vss.n1938 0.0308013
R4911 vss.n2001 vss.n1939 0.0308013
R4912 vss.n2007 vss.n1940 0.0308013
R4913 vss.n2011 vss.n1941 0.0308013
R4914 vss.n1943 vss.n1942 0.0308013
R4915 vss.n1872 vss.n1843 0.0308013
R4916 vss.n1878 vss.n1844 0.0308013
R4917 vss.n1882 vss.n1845 0.0308013
R4918 vss.n1888 vss.n1846 0.0308013
R4919 vss.n1892 vss.n1847 0.0308013
R4920 vss.n1899 vss.n1848 0.0308013
R4921 vss.n1903 vss.n1849 0.0308013
R4922 vss.n1909 vss.n1850 0.0308013
R4923 vss.n1913 vss.n1851 0.0308013
R4924 vss.n1919 vss.n1852 0.0308013
R4925 vss.n1923 vss.n1853 0.0308013
R4926 vss.n1855 vss.n1854 0.0308013
R4927 vss.n1784 vss.n1755 0.0308013
R4928 vss.n1790 vss.n1756 0.0308013
R4929 vss.n1794 vss.n1757 0.0308013
R4930 vss.n1800 vss.n1758 0.0308013
R4931 vss.n1804 vss.n1759 0.0308013
R4932 vss.n1811 vss.n1760 0.0308013
R4933 vss.n1815 vss.n1761 0.0308013
R4934 vss.n1821 vss.n1762 0.0308013
R4935 vss.n1825 vss.n1763 0.0308013
R4936 vss.n1831 vss.n1764 0.0308013
R4937 vss.n1835 vss.n1765 0.0308013
R4938 vss.n1767 vss.n1766 0.0308013
R4939 vss.n1696 vss.n1667 0.0308013
R4940 vss.n1702 vss.n1668 0.0308013
R4941 vss.n1706 vss.n1669 0.0308013
R4942 vss.n1712 vss.n1670 0.0308013
R4943 vss.n1716 vss.n1671 0.0308013
R4944 vss.n1723 vss.n1672 0.0308013
R4945 vss.n1727 vss.n1673 0.0308013
R4946 vss.n1733 vss.n1674 0.0308013
R4947 vss.n1737 vss.n1675 0.0308013
R4948 vss.n1743 vss.n1676 0.0308013
R4949 vss.n1747 vss.n1677 0.0308013
R4950 vss.n1679 vss.n1678 0.0308013
R4951 vss.n1608 vss.n1579 0.0308013
R4952 vss.n1614 vss.n1580 0.0308013
R4953 vss.n1618 vss.n1581 0.0308013
R4954 vss.n1624 vss.n1582 0.0308013
R4955 vss.n1628 vss.n1583 0.0308013
R4956 vss.n1635 vss.n1584 0.0308013
R4957 vss.n1639 vss.n1585 0.0308013
R4958 vss.n1645 vss.n1586 0.0308013
R4959 vss.n1649 vss.n1587 0.0308013
R4960 vss.n1655 vss.n1588 0.0308013
R4961 vss.n1659 vss.n1589 0.0308013
R4962 vss.n1591 vss.n1590 0.0308013
R4963 vss.n1660 vss.n1590 0.0308013
R4964 vss.n1656 vss.n1589 0.0308013
R4965 vss.n1650 vss.n1588 0.0308013
R4966 vss.n1646 vss.n1587 0.0308013
R4967 vss.n1640 vss.n1586 0.0308013
R4968 vss.n1636 vss.n1585 0.0308013
R4969 vss.n1629 vss.n1584 0.0308013
R4970 vss.n1625 vss.n1583 0.0308013
R4971 vss.n1619 vss.n1582 0.0308013
R4972 vss.n1615 vss.n1581 0.0308013
R4973 vss.n1609 vss.n1580 0.0308013
R4974 vss.n1605 vss.n1579 0.0308013
R4975 vss.n1748 vss.n1678 0.0308013
R4976 vss.n1744 vss.n1677 0.0308013
R4977 vss.n1738 vss.n1676 0.0308013
R4978 vss.n1734 vss.n1675 0.0308013
R4979 vss.n1728 vss.n1674 0.0308013
R4980 vss.n1724 vss.n1673 0.0308013
R4981 vss.n1717 vss.n1672 0.0308013
R4982 vss.n1713 vss.n1671 0.0308013
R4983 vss.n1707 vss.n1670 0.0308013
R4984 vss.n1703 vss.n1669 0.0308013
R4985 vss.n1697 vss.n1668 0.0308013
R4986 vss.n1693 vss.n1667 0.0308013
R4987 vss.n1836 vss.n1766 0.0308013
R4988 vss.n1832 vss.n1765 0.0308013
R4989 vss.n1826 vss.n1764 0.0308013
R4990 vss.n1822 vss.n1763 0.0308013
R4991 vss.n1816 vss.n1762 0.0308013
R4992 vss.n1812 vss.n1761 0.0308013
R4993 vss.n1805 vss.n1760 0.0308013
R4994 vss.n1801 vss.n1759 0.0308013
R4995 vss.n1795 vss.n1758 0.0308013
R4996 vss.n1791 vss.n1757 0.0308013
R4997 vss.n1785 vss.n1756 0.0308013
R4998 vss.n1781 vss.n1755 0.0308013
R4999 vss.n1924 vss.n1854 0.0308013
R5000 vss.n1920 vss.n1853 0.0308013
R5001 vss.n1914 vss.n1852 0.0308013
R5002 vss.n1910 vss.n1851 0.0308013
R5003 vss.n1904 vss.n1850 0.0308013
R5004 vss.n1900 vss.n1849 0.0308013
R5005 vss.n1893 vss.n1848 0.0308013
R5006 vss.n1889 vss.n1847 0.0308013
R5007 vss.n1883 vss.n1846 0.0308013
R5008 vss.n1879 vss.n1845 0.0308013
R5009 vss.n1873 vss.n1844 0.0308013
R5010 vss.n1869 vss.n1843 0.0308013
R5011 vss.n2012 vss.n1942 0.0308013
R5012 vss.n2008 vss.n1941 0.0308013
R5013 vss.n2002 vss.n1940 0.0308013
R5014 vss.n1998 vss.n1939 0.0308013
R5015 vss.n1992 vss.n1938 0.0308013
R5016 vss.n1988 vss.n1937 0.0308013
R5017 vss.n1981 vss.n1936 0.0308013
R5018 vss.n1977 vss.n1935 0.0308013
R5019 vss.n1971 vss.n1934 0.0308013
R5020 vss.n1967 vss.n1933 0.0308013
R5021 vss.n1961 vss.n1932 0.0308013
R5022 vss.n1957 vss.n1931 0.0308013
R5023 vss.n2100 vss.n2030 0.0308013
R5024 vss.n2096 vss.n2029 0.0308013
R5025 vss.n2090 vss.n2028 0.0308013
R5026 vss.n2086 vss.n2027 0.0308013
R5027 vss.n2080 vss.n2026 0.0308013
R5028 vss.n2076 vss.n2025 0.0308013
R5029 vss.n2069 vss.n2024 0.0308013
R5030 vss.n2065 vss.n2023 0.0308013
R5031 vss.n2059 vss.n2022 0.0308013
R5032 vss.n2055 vss.n2021 0.0308013
R5033 vss.n2049 vss.n2020 0.0308013
R5034 vss.n2045 vss.n2019 0.0308013
R5035 vss.n2188 vss.n2118 0.0308013
R5036 vss.n2184 vss.n2117 0.0308013
R5037 vss.n2178 vss.n2116 0.0308013
R5038 vss.n2174 vss.n2115 0.0308013
R5039 vss.n2168 vss.n2114 0.0308013
R5040 vss.n2164 vss.n2113 0.0308013
R5041 vss.n2157 vss.n2112 0.0308013
R5042 vss.n2153 vss.n2111 0.0308013
R5043 vss.n2147 vss.n2110 0.0308013
R5044 vss.n2143 vss.n2109 0.0308013
R5045 vss.n2137 vss.n2108 0.0308013
R5046 vss.n2133 vss.n2107 0.0308013
R5047 vss.n2276 vss.n2206 0.0308013
R5048 vss.n2272 vss.n2205 0.0308013
R5049 vss.n2266 vss.n2204 0.0308013
R5050 vss.n2262 vss.n2203 0.0308013
R5051 vss.n2256 vss.n2202 0.0308013
R5052 vss.n2252 vss.n2201 0.0308013
R5053 vss.n2245 vss.n2200 0.0308013
R5054 vss.n2241 vss.n2199 0.0308013
R5055 vss.n2235 vss.n2198 0.0308013
R5056 vss.n2231 vss.n2197 0.0308013
R5057 vss.n2225 vss.n2196 0.0308013
R5058 vss.n2221 vss.n2195 0.0308013
R5059 vss.n2442 vss.n2413 0.0308013
R5060 vss.n2448 vss.n2414 0.0308013
R5061 vss.n2452 vss.n2415 0.0308013
R5062 vss.n2458 vss.n2416 0.0308013
R5063 vss.n2462 vss.n2417 0.0308013
R5064 vss.n2469 vss.n2418 0.0308013
R5065 vss.n2473 vss.n2419 0.0308013
R5066 vss.n2479 vss.n2420 0.0308013
R5067 vss.n2483 vss.n2421 0.0308013
R5068 vss.n2489 vss.n2422 0.0308013
R5069 vss.n2493 vss.n2423 0.0308013
R5070 vss.n2425 vss.n2424 0.0308013
R5071 vss.n2354 vss.n2325 0.0308013
R5072 vss.n2360 vss.n2326 0.0308013
R5073 vss.n2364 vss.n2327 0.0308013
R5074 vss.n2370 vss.n2328 0.0308013
R5075 vss.n2374 vss.n2329 0.0308013
R5076 vss.n2381 vss.n2330 0.0308013
R5077 vss.n2385 vss.n2331 0.0308013
R5078 vss.n2391 vss.n2332 0.0308013
R5079 vss.n2395 vss.n2333 0.0308013
R5080 vss.n2401 vss.n2334 0.0308013
R5081 vss.n2405 vss.n2335 0.0308013
R5082 vss.n2337 vss.n2336 0.0308013
R5083 vss.n2406 vss.n2336 0.0308013
R5084 vss.n2402 vss.n2335 0.0308013
R5085 vss.n2396 vss.n2334 0.0308013
R5086 vss.n2392 vss.n2333 0.0308013
R5087 vss.n2386 vss.n2332 0.0308013
R5088 vss.n2382 vss.n2331 0.0308013
R5089 vss.n2375 vss.n2330 0.0308013
R5090 vss.n2371 vss.n2329 0.0308013
R5091 vss.n2365 vss.n2328 0.0308013
R5092 vss.n2361 vss.n2327 0.0308013
R5093 vss.n2355 vss.n2326 0.0308013
R5094 vss.n2351 vss.n2325 0.0308013
R5095 vss.n2494 vss.n2424 0.0308013
R5096 vss.n2490 vss.n2423 0.0308013
R5097 vss.n2484 vss.n2422 0.0308013
R5098 vss.n2480 vss.n2421 0.0308013
R5099 vss.n2474 vss.n2420 0.0308013
R5100 vss.n2470 vss.n2419 0.0308013
R5101 vss.n2463 vss.n2418 0.0308013
R5102 vss.n2459 vss.n2417 0.0308013
R5103 vss.n2453 vss.n2416 0.0308013
R5104 vss.n2449 vss.n2415 0.0308013
R5105 vss.n2443 vss.n2414 0.0308013
R5106 vss.n2439 vss.n2413 0.0308013
R5107 vss.n2800 vss.n2771 0.0308013
R5108 vss.n2806 vss.n2772 0.0308013
R5109 vss.n2810 vss.n2773 0.0308013
R5110 vss.n2816 vss.n2774 0.0308013
R5111 vss.n2820 vss.n2775 0.0308013
R5112 vss.n2827 vss.n2776 0.0308013
R5113 vss.n2831 vss.n2777 0.0308013
R5114 vss.n2837 vss.n2778 0.0308013
R5115 vss.n2841 vss.n2779 0.0308013
R5116 vss.n2847 vss.n2780 0.0308013
R5117 vss.n2851 vss.n2781 0.0308013
R5118 vss.n2783 vss.n2782 0.0308013
R5119 vss.n2712 vss.n2683 0.0308013
R5120 vss.n2718 vss.n2684 0.0308013
R5121 vss.n2722 vss.n2685 0.0308013
R5122 vss.n2728 vss.n2686 0.0308013
R5123 vss.n2732 vss.n2687 0.0308013
R5124 vss.n2739 vss.n2688 0.0308013
R5125 vss.n2743 vss.n2689 0.0308013
R5126 vss.n2749 vss.n2690 0.0308013
R5127 vss.n2753 vss.n2691 0.0308013
R5128 vss.n2759 vss.n2692 0.0308013
R5129 vss.n2763 vss.n2693 0.0308013
R5130 vss.n2695 vss.n2694 0.0308013
R5131 vss.n2624 vss.n2595 0.0308013
R5132 vss.n2630 vss.n2596 0.0308013
R5133 vss.n2634 vss.n2597 0.0308013
R5134 vss.n2640 vss.n2598 0.0308013
R5135 vss.n2644 vss.n2599 0.0308013
R5136 vss.n2651 vss.n2600 0.0308013
R5137 vss.n2655 vss.n2601 0.0308013
R5138 vss.n2661 vss.n2602 0.0308013
R5139 vss.n2665 vss.n2603 0.0308013
R5140 vss.n2671 vss.n2604 0.0308013
R5141 vss.n2675 vss.n2605 0.0308013
R5142 vss.n2607 vss.n2606 0.0308013
R5143 vss.n2536 vss.n2507 0.0308013
R5144 vss.n2542 vss.n2508 0.0308013
R5145 vss.n2546 vss.n2509 0.0308013
R5146 vss.n2552 vss.n2510 0.0308013
R5147 vss.n2556 vss.n2511 0.0308013
R5148 vss.n2563 vss.n2512 0.0308013
R5149 vss.n2567 vss.n2513 0.0308013
R5150 vss.n2573 vss.n2514 0.0308013
R5151 vss.n2577 vss.n2515 0.0308013
R5152 vss.n2583 vss.n2516 0.0308013
R5153 vss.n2587 vss.n2517 0.0308013
R5154 vss.n2519 vss.n2518 0.0308013
R5155 vss.n2588 vss.n2518 0.0308013
R5156 vss.n2584 vss.n2517 0.0308013
R5157 vss.n2578 vss.n2516 0.0308013
R5158 vss.n2574 vss.n2515 0.0308013
R5159 vss.n2568 vss.n2514 0.0308013
R5160 vss.n2564 vss.n2513 0.0308013
R5161 vss.n2557 vss.n2512 0.0308013
R5162 vss.n2553 vss.n2511 0.0308013
R5163 vss.n2547 vss.n2510 0.0308013
R5164 vss.n2543 vss.n2509 0.0308013
R5165 vss.n2537 vss.n2508 0.0308013
R5166 vss.n2533 vss.n2507 0.0308013
R5167 vss.n2676 vss.n2606 0.0308013
R5168 vss.n2672 vss.n2605 0.0308013
R5169 vss.n2666 vss.n2604 0.0308013
R5170 vss.n2662 vss.n2603 0.0308013
R5171 vss.n2656 vss.n2602 0.0308013
R5172 vss.n2652 vss.n2601 0.0308013
R5173 vss.n2645 vss.n2600 0.0308013
R5174 vss.n2641 vss.n2599 0.0308013
R5175 vss.n2635 vss.n2598 0.0308013
R5176 vss.n2631 vss.n2597 0.0308013
R5177 vss.n2625 vss.n2596 0.0308013
R5178 vss.n2621 vss.n2595 0.0308013
R5179 vss.n2764 vss.n2694 0.0308013
R5180 vss.n2760 vss.n2693 0.0308013
R5181 vss.n2754 vss.n2692 0.0308013
R5182 vss.n2750 vss.n2691 0.0308013
R5183 vss.n2744 vss.n2690 0.0308013
R5184 vss.n2740 vss.n2689 0.0308013
R5185 vss.n2733 vss.n2688 0.0308013
R5186 vss.n2729 vss.n2687 0.0308013
R5187 vss.n2723 vss.n2686 0.0308013
R5188 vss.n2719 vss.n2685 0.0308013
R5189 vss.n2713 vss.n2684 0.0308013
R5190 vss.n2709 vss.n2683 0.0308013
R5191 vss.n2852 vss.n2782 0.0308013
R5192 vss.n2848 vss.n2781 0.0308013
R5193 vss.n2842 vss.n2780 0.0308013
R5194 vss.n2838 vss.n2779 0.0308013
R5195 vss.n2832 vss.n2778 0.0308013
R5196 vss.n2828 vss.n2777 0.0308013
R5197 vss.n2821 vss.n2776 0.0308013
R5198 vss.n2817 vss.n2775 0.0308013
R5199 vss.n2811 vss.n2774 0.0308013
R5200 vss.n2807 vss.n2773 0.0308013
R5201 vss.n2801 vss.n2772 0.0308013
R5202 vss.n2797 vss.n2771 0.0308013
R5203 vss.n98 vss.n82 0.0308013
R5204 vss.n102 vss.n83 0.0308013
R5205 vss.n109 vss.n84 0.0308013
R5206 vss.n113 vss.n85 0.0308013
R5207 vss.n87 vss.n86 0.0308013
R5208 vss.n114 vss.n86 0.0308013
R5209 vss.n110 vss.n85 0.0308013
R5210 vss.n103 vss.n84 0.0308013
R5211 vss.n99 vss.n83 0.0308013
R5212 vss.n93 vss.n82 0.0308013
R5213 vss.n71 vss.n70 0.0308013
R5214 vss.n133 vss.n123 0.0308013
R5215 vss.n125 vss.n124 0.0308013
R5216 vss.n134 vss.n124 0.0308013
R5217 vss.n128 vss.n123 0.0308013
R5218 vss.n1495 vss.n1493 0.0306053
R5219 vss.n1552 vss.n1481 0.0306053
R5220 vss.n1407 vss.n1405 0.0306053
R5221 vss.n1464 vss.n1393 0.0306053
R5222 vss.n1319 vss.n1317 0.0306053
R5223 vss.n1376 vss.n1305 0.0306053
R5224 vss.n1231 vss.n1229 0.0306053
R5225 vss.n1288 vss.n1217 0.0306053
R5226 vss.n1143 vss.n1141 0.0306053
R5227 vss.n1200 vss.n1129 0.0306053
R5228 vss.n1055 vss.n1053 0.0306053
R5229 vss.n1112 vss.n1041 0.0306053
R5230 vss.n967 vss.n965 0.0306053
R5231 vss.n1024 vss.n953 0.0306053
R5232 vss.n879 vss.n877 0.0306053
R5233 vss.n936 vss.n865 0.0306053
R5234 vss.n791 vss.n789 0.0306053
R5235 vss.n848 vss.n777 0.0306053
R5236 vss.n703 vss.n701 0.0306053
R5237 vss.n760 vss.n689 0.0306053
R5238 vss.n615 vss.n613 0.0306053
R5239 vss.n672 vss.n601 0.0306053
R5240 vss.n527 vss.n525 0.0306053
R5241 vss.n584 vss.n513 0.0306053
R5242 vss.n439 vss.n437 0.0306053
R5243 vss.n496 vss.n425 0.0306053
R5244 vss.n351 vss.n349 0.0306053
R5245 vss.n408 vss.n337 0.0306053
R5246 vss.n263 vss.n261 0.0306053
R5247 vss.n320 vss.n249 0.0306053
R5248 vss.n175 vss.n173 0.0306053
R5249 vss.n232 vss.n161 0.0306053
R5250 vss.n2222 vss.n2220 0.0306053
R5251 vss.n2279 vss.n2208 0.0306053
R5252 vss.n2134 vss.n2132 0.0306053
R5253 vss.n2191 vss.n2120 0.0306053
R5254 vss.n2046 vss.n2044 0.0306053
R5255 vss.n2103 vss.n2032 0.0306053
R5256 vss.n1958 vss.n1956 0.0306053
R5257 vss.n2015 vss.n1944 0.0306053
R5258 vss.n1870 vss.n1868 0.0306053
R5259 vss.n1927 vss.n1856 0.0306053
R5260 vss.n1782 vss.n1780 0.0306053
R5261 vss.n1839 vss.n1768 0.0306053
R5262 vss.n1694 vss.n1692 0.0306053
R5263 vss.n1751 vss.n1680 0.0306053
R5264 vss.n1606 vss.n1604 0.0306053
R5265 vss.n1663 vss.n1592 0.0306053
R5266 vss.n2440 vss.n2438 0.0306053
R5267 vss.n2497 vss.n2426 0.0306053
R5268 vss.n2352 vss.n2350 0.0306053
R5269 vss.n2409 vss.n2338 0.0306053
R5270 vss.n2798 vss.n2796 0.0306053
R5271 vss.n2855 vss.n2784 0.0306053
R5272 vss.n2710 vss.n2708 0.0306053
R5273 vss.n2767 vss.n2696 0.0306053
R5274 vss.n2622 vss.n2620 0.0306053
R5275 vss.n2679 vss.n2608 0.0306053
R5276 vss.n2534 vss.n2532 0.0306053
R5277 vss.n2591 vss.n2520 0.0306053
R5278 vss.n2911 vss.n2910 0.0306053
R5279 vss.n2970 vss.n2874 0.0306053
R5280 vss.n95 vss.n94 0.0306053
R5281 vss.n117 vss.n88 0.0306053
R5282 vss.n73 vss.n72 0.0306053
R5283 vss.n130 vss.n129 0.0306053
R5284 vss.n137 vss.n126 0.0306053
R5285 vss.n1522 vss.n1521 0.0305
R5286 vss.n1523 vss.n1522 0.0305
R5287 vss.n1434 vss.n1433 0.0305
R5288 vss.n1435 vss.n1434 0.0305
R5289 vss.n1346 vss.n1345 0.0305
R5290 vss.n1347 vss.n1346 0.0305
R5291 vss.n1258 vss.n1257 0.0305
R5292 vss.n1259 vss.n1258 0.0305
R5293 vss.n1170 vss.n1169 0.0305
R5294 vss.n1171 vss.n1170 0.0305
R5295 vss.n1082 vss.n1081 0.0305
R5296 vss.n1083 vss.n1082 0.0305
R5297 vss.n994 vss.n993 0.0305
R5298 vss.n995 vss.n994 0.0305
R5299 vss.n906 vss.n905 0.0305
R5300 vss.n907 vss.n906 0.0305
R5301 vss.n818 vss.n817 0.0305
R5302 vss.n819 vss.n818 0.0305
R5303 vss.n730 vss.n729 0.0305
R5304 vss.n731 vss.n730 0.0305
R5305 vss.n642 vss.n641 0.0305
R5306 vss.n643 vss.n642 0.0305
R5307 vss.n554 vss.n553 0.0305
R5308 vss.n555 vss.n554 0.0305
R5309 vss.n466 vss.n465 0.0305
R5310 vss.n467 vss.n466 0.0305
R5311 vss.n378 vss.n377 0.0305
R5312 vss.n379 vss.n378 0.0305
R5313 vss.n290 vss.n289 0.0305
R5314 vss.n291 vss.n290 0.0305
R5315 vss.n202 vss.n201 0.0305
R5316 vss.n203 vss.n202 0.0305
R5317 vss.n2249 vss.n2248 0.0305
R5318 vss.n2250 vss.n2249 0.0305
R5319 vss.n2161 vss.n2160 0.0305
R5320 vss.n2162 vss.n2161 0.0305
R5321 vss.n2073 vss.n2072 0.0305
R5322 vss.n2074 vss.n2073 0.0305
R5323 vss.n1985 vss.n1984 0.0305
R5324 vss.n1986 vss.n1985 0.0305
R5325 vss.n1897 vss.n1896 0.0305
R5326 vss.n1898 vss.n1897 0.0305
R5327 vss.n1809 vss.n1808 0.0305
R5328 vss.n1810 vss.n1809 0.0305
R5329 vss.n1721 vss.n1720 0.0305
R5330 vss.n1722 vss.n1721 0.0305
R5331 vss.n1633 vss.n1632 0.0305
R5332 vss.n1634 vss.n1633 0.0305
R5333 vss.n2467 vss.n2466 0.0305
R5334 vss.n2468 vss.n2467 0.0305
R5335 vss.n2379 vss.n2378 0.0305
R5336 vss.n2380 vss.n2379 0.0305
R5337 vss.n2825 vss.n2824 0.0305
R5338 vss.n2826 vss.n2825 0.0305
R5339 vss.n2737 vss.n2736 0.0305
R5340 vss.n2738 vss.n2737 0.0305
R5341 vss.n2649 vss.n2648 0.0305
R5342 vss.n2650 vss.n2649 0.0305
R5343 vss.n2561 vss.n2560 0.0305
R5344 vss.n2562 vss.n2561 0.0305
R5345 vss.n2940 vss.n2939 0.0305
R5346 vss.n2941 vss.n2940 0.0305
R5347 vss.n106 vss.n105 0.0305
R5348 vss.n107 vss.n106 0.0305
R5349 vss.n131 vss.n127 0.0305
R5350 vss.n136 vss.n127 0.0305
R5351 vss.n322 vss.n234 0.0287857
R5352 vss.n410 vss.n322 0.0287857
R5353 vss.n498 vss.n410 0.0287857
R5354 vss.n586 vss.n498 0.0287857
R5355 vss.n674 vss.n586 0.0287857
R5356 vss.n762 vss.n674 0.0287857
R5357 vss.n850 vss.n762 0.0287857
R5358 vss.n938 vss.n850 0.0287857
R5359 vss.n1026 vss.n938 0.0287857
R5360 vss.n1114 vss.n1026 0.0287857
R5361 vss.n1202 vss.n1114 0.0287857
R5362 vss.n1290 vss.n1202 0.0287857
R5363 vss.n1378 vss.n1290 0.0287857
R5364 vss.n1466 vss.n1378 0.0287857
R5365 vss.n1554 vss.n1466 0.0287857
R5366 vss.n1753 vss.n1665 0.0287857
R5367 vss.n1841 vss.n1753 0.0287857
R5368 vss.n1929 vss.n1841 0.0287857
R5369 vss.n2017 vss.n1929 0.0287857
R5370 vss.n2105 vss.n2017 0.0287857
R5371 vss.n2193 vss.n2105 0.0287857
R5372 vss.n2281 vss.n2193 0.0287857
R5373 vss.n2499 vss.n2411 0.0287857
R5374 vss.n2681 vss.n2593 0.0287857
R5375 vss.n2769 vss.n2681 0.0287857
R5376 vss.n2857 vss.n2769 0.0287857
R5377 vss vss.n0 0.021875
R5378 vss.n1562 vss.n1556 0.0039231
R5379 vss.n1568 vss.n1565 0.0039231
R5380 vss.n1564 vss.n1561 0.0039231
R5381 vss.n1569 vss.n1567 0.0039231
R5382 vss.n1566 vss.n1560 0.0039231
R5383 vss.n2314 vss.n1571 0.0039231
R5384 vss.n2291 vss.n1575 0.0039231
R5385 vss.n2303 vss.n2294 0.0039231
R5386 vss.n2293 vss.n1574 0.0039231
R5387 vss.n2304 vss.n2296 0.0039231
R5388 vss.n2295 vss.n1573 0.0039231
R5389 vss.n2308 vss.n2297 0.0039231
R5390 vss.n17 vss.n15 0.0039231
R5391 vss.n3047 vss.n20 0.0039231
R5392 vss.n19 vss.n14 0.0039231
R5393 vss.n3048 vss.n22 0.0039231
R5394 vss.n21 vss.n13 0.0039231
R5395 vss.n3052 vss.n23 0.0039231
R5396 vss.n5 vss.n3 0.0039231
R5397 vss.n3059 vss.n8 0.0039231
R5398 vss.n7 vss.n2 0.0039231
R5399 vss.n3060 vss.n10 0.0039231
R5400 vss.n9 vss.n1 0.0039231
R5401 vss.n3064 vss.n11 0.0039231
R5402 vss.n29 vss.n27 0.0039231
R5403 vss.n3035 vss.n32 0.0039231
R5404 vss.n31 vss.n26 0.0039231
R5405 vss.n3036 vss.n34 0.0039231
R5406 vss.n33 vss.n25 0.0039231
R5407 vss.n3040 vss.n35 0.0039231
R5408 vss.n41 vss.n39 0.0039231
R5409 vss.n3023 vss.n44 0.0039231
R5410 vss.n43 vss.n38 0.0039231
R5411 vss.n3024 vss.n46 0.0039231
R5412 vss.n45 vss.n37 0.0039231
R5413 vss.n3028 vss.n47 0.0039231
R5414 vss.n2987 vss.n2981 0.0039231
R5415 vss.n2993 vss.n2990 0.0039231
R5416 vss.n2989 vss.n2986 0.0039231
R5417 vss.n2994 vss.n2992 0.0039231
R5418 vss.n2991 vss.n2985 0.0039231
R5419 vss.n3002 vss.n2996 0.0039231
R5420 vss.n3013 vss.n3012 0.0039231
R5421 vss.n64 vss.n53 0.0039231
R5422 vss.n57 vss.n50 0.0039231
R5423 vss.n65 vss.n54 0.0039231
R5424 vss.n56 vss.n49 0.0039231
R5425 vss.n3016 vss.n55 0.0039231
R5426 vss.n3012 vss.n51 0.0039231
R5427 vss.n64 vss.n51 0.0039231
R5428 vss.n57 vss.n53 0.0039231
R5429 vss.n65 vss.n50 0.0039231
R5430 vss.n56 vss.n54 0.0039231
R5431 vss.n55 vss.n49 0.0039231
R5432 vss.n3004 vss.n2981 0.0039231
R5433 vss.n2993 vss.n2987 0.0039231
R5434 vss.n2990 vss.n2989 0.0039231
R5435 vss.n2994 vss.n2986 0.0039231
R5436 vss.n2992 vss.n2991 0.0039231
R5437 vss.n2996 vss.n2985 0.0039231
R5438 vss.n42 vss.n41 0.0039231
R5439 vss.n3023 vss.n39 0.0039231
R5440 vss.n44 vss.n43 0.0039231
R5441 vss.n3024 vss.n38 0.0039231
R5442 vss.n46 vss.n45 0.0039231
R5443 vss.n47 vss.n37 0.0039231
R5444 vss.n30 vss.n29 0.0039231
R5445 vss.n3035 vss.n27 0.0039231
R5446 vss.n32 vss.n31 0.0039231
R5447 vss.n3036 vss.n26 0.0039231
R5448 vss.n34 vss.n33 0.0039231
R5449 vss.n35 vss.n25 0.0039231
R5450 vss.n2316 vss.n1556 0.0039231
R5451 vss.n1568 vss.n1562 0.0039231
R5452 vss.n1565 vss.n1564 0.0039231
R5453 vss.n1569 vss.n1561 0.0039231
R5454 vss.n1567 vss.n1566 0.0039231
R5455 vss.n1571 vss.n1560 0.0039231
R5456 vss.n6 vss.n5 0.0039231
R5457 vss.n3059 vss.n3 0.0039231
R5458 vss.n8 vss.n7 0.0039231
R5459 vss.n3060 vss.n2 0.0039231
R5460 vss.n10 vss.n9 0.0039231
R5461 vss.n11 vss.n1 0.0039231
R5462 vss.n18 vss.n17 0.0039231
R5463 vss.n3047 vss.n15 0.0039231
R5464 vss.n20 vss.n19 0.0039231
R5465 vss.n3048 vss.n14 0.0039231
R5466 vss.n22 vss.n21 0.0039231
R5467 vss.n23 vss.n13 0.0039231
R5468 vss.n2292 vss.n2291 0.0039231
R5469 vss.n2303 vss.n1575 0.0039231
R5470 vss.n2294 vss.n2293 0.0039231
R5471 vss.n2304 vss.n1574 0.0039231
R5472 vss.n2296 vss.n2295 0.0039231
R5473 vss.n2297 vss.n1573 0.0039231
R5474 vss.n2913 vss.n2908 0.00334211
R5475 vss.n2914 vss.n2913 0.00334211
R5476 vss.n2915 vss.n2914 0.00334211
R5477 vss.n2915 vss.n2902 0.00334211
R5478 vss.n2923 vss.n2902 0.00334211
R5479 vss.n2924 vss.n2923 0.00334211
R5480 vss.n2925 vss.n2924 0.00334211
R5481 vss.n2925 vss.n2896 0.00334211
R5482 vss.n2933 vss.n2896 0.00334211
R5483 vss.n2934 vss.n2933 0.00334211
R5484 vss.n2935 vss.n2934 0.00334211
R5485 vss.n2935 vss.n2890 0.00334211
R5486 vss.n2944 vss.n2890 0.00334211
R5487 vss.n2945 vss.n2944 0.00334211
R5488 vss.n2946 vss.n2945 0.00334211
R5489 vss.n2946 vss.n2884 0.00334211
R5490 vss.n2954 vss.n2884 0.00334211
R5491 vss.n2955 vss.n2954 0.00334211
R5492 vss.n2956 vss.n2955 0.00334211
R5493 vss.n2956 vss.n2878 0.00334211
R5494 vss.n2964 vss.n2878 0.00334211
R5495 vss.n2965 vss.n2964 0.00334211
R5496 vss.n2966 vss.n2965 0.00334211
R5497 vss.n2966 vss.n2872 0.00334211
R5498 vss.n2972 vss.n2872 0.00334211
R5499 vss.n2315 vss.n1563 0.002125
R5500 vss.n1570 vss.n1559 0.002125
R5501 vss.n2309 vss.n1576 0.002125
R5502 vss.n2306 vss.n2305 0.002125
R5503 vss.n3065 vss.n4 0.002125
R5504 vss.n3062 vss.n3061 0.002125
R5505 vss.n3053 vss.n16 0.002125
R5506 vss.n3050 vss.n3049 0.002125
R5507 vss.n3041 vss.n28 0.002125
R5508 vss.n3038 vss.n3037 0.002125
R5509 vss.n3029 vss.n40 0.002125
R5510 vss.n3026 vss.n3025 0.002125
R5511 vss.n3015 vss.n66 0.002125
R5512 vss.n3003 vss.n2988 0.002125
R5513 vss.n2995 vss.n2984 0.002125
R5514 vss.n2313 vss.n1559 0.00181235
R5515 vss.n1570 vss.n1557 0.00181235
R5516 vss.n2311 vss.n1572 0.00181235
R5517 vss.n1572 vss.n1558 0.00181235
R5518 vss.n2307 vss.n2306 0.00181235
R5519 vss.n2305 vss.n2302 0.00181235
R5520 vss.n2300 vss.n2299 0.00181235
R5521 vss.n2299 vss.n2298 0.00181235
R5522 vss.n3063 vss.n3062 0.00181235
R5523 vss.n3061 vss.n3058 0.00181235
R5524 vss.n3056 vss.n12 0.00181235
R5525 vss.n3054 vss.n12 0.00181235
R5526 vss.n3051 vss.n3050 0.00181235
R5527 vss.n3049 vss.n3046 0.00181235
R5528 vss.n3044 vss.n24 0.00181235
R5529 vss.n3042 vss.n24 0.00181235
R5530 vss.n3039 vss.n3038 0.00181235
R5531 vss.n3037 vss.n3034 0.00181235
R5532 vss.n3032 vss.n36 0.00181235
R5533 vss.n3030 vss.n36 0.00181235
R5534 vss.n3027 vss.n3026 0.00181235
R5535 vss.n3025 vss.n3022 0.00181235
R5536 vss.n3020 vss.n48 0.00181235
R5537 vss.n3018 vss.n48 0.00181235
R5538 vss.n3017 vss.n52 0.00181235
R5539 vss.n3015 vss.n3014 0.00181235
R5540 vss.n62 vss.n58 0.00181235
R5541 vss.n3011 vss.n63 0.00181235
R5542 vss.n60 vss.n59 0.00181235
R5543 vss.n3001 vss.n2984 0.00181235
R5544 vss.n2995 vss.n2982 0.00181235
R5545 vss.n2999 vss.n2997 0.00181235
R5546 vss.n2997 vss.n2983 0.00181235
R5547 vss.n3011 vss.n59 0.00181235
R5548 vss.n3014 vss.n58 0.00181235
R5549 vss.n66 vss.n52 0.00181235
R5550 vss.n63 vss.n62 0.00181235
R5551 vss.n61 vss.n60 0.00181235
R5552 vss.n2998 vss.n2983 0.00181235
R5553 vss.n3000 vss.n2982 0.00181235
R5554 vss.n3000 vss.n2999 0.00181235
R5555 vss.n3001 vss.n2988 0.00181235
R5556 vss.n3019 vss.n3018 0.00181235
R5557 vss.n3022 vss.n3021 0.00181235
R5558 vss.n3021 vss.n3020 0.00181235
R5559 vss.n3027 vss.n40 0.00181235
R5560 vss.n3031 vss.n3030 0.00181235
R5561 vss.n3034 vss.n3033 0.00181235
R5562 vss.n3033 vss.n3032 0.00181235
R5563 vss.n3039 vss.n28 0.00181235
R5564 vss.n2310 vss.n1558 0.00181235
R5565 vss.n2312 vss.n1557 0.00181235
R5566 vss.n2312 vss.n2311 0.00181235
R5567 vss.n2313 vss.n1563 0.00181235
R5568 vss.n3055 vss.n3054 0.00181235
R5569 vss.n3058 vss.n3057 0.00181235
R5570 vss.n3057 vss.n3056 0.00181235
R5571 vss.n3063 vss.n4 0.00181235
R5572 vss.n3043 vss.n3042 0.00181235
R5573 vss.n3046 vss.n3045 0.00181235
R5574 vss.n3045 vss.n3044 0.00181235
R5575 vss.n3051 vss.n16 0.00181235
R5576 vss.n2298 vss.n0 0.00181235
R5577 vss.n2302 vss.n2301 0.00181235
R5578 vss.n2301 vss.n2300 0.00181235
R5579 vss.n2307 vss.n1576 0.00181235
C0 d1 voutp 0.47018f
C1 d2b voutp 0.19472f
C2 d7b voutp 0.2249f
C3 voutn d4b 0.45229f
C4 d2 a_14000_6896# 0.0288f
C5 d0b voutp 0.18882f
C6 d6b voutp 0.21833f
C7 voutn d3b 0.42553f
C8 d1 a_8800_6448# 0.02179f
C9 vb d1b 0
C10 vb voutn 32.6056f
C11 a_14000_6896# d2b 0.5563f
C12 d7b a_52100_11736# 1.22368f
C13 d5b voutp 0.21014f
C14 a_3600_6224# d0b 0.54318f
C15 d6b a_39200_10780# 0.88892f
C16 vb d4b 0
C17 a_30700_9584# voutp 1.13852f
C18 a_30700_9584# d5b 0.71982f
C19 voutp a_19200_7792# 0.34614f
C20 a_3600_6224# voutp 0.20257f
C21 voutp a_24400_9584# 0.46381f
C22 a_8800_6448# voutp 0.21228f
C23 voutp a_39200_10780# 2.34324f
C24 vb d3b 0
C25 a_14000_6896# voutp 0.24419f
C26 voutp a_52100_11736# 4.86094f
C27 d4 voutp 0.51911f
C28 d3 voutp 0.4944f
C29 d0 d0b 0.3794f
C30 d1 d1b 0.3796f
C31 voutn d2b 0.40985f
C32 d7b voutn 1.67986f
C33 d4 a_24400_9584# 0.07015f
C34 d0 voutp 0.4661f
C35 d3 a_19200_7792# 0.04358f
C36 voutn d0b 0.39842f
C37 d7b d7 0.38617f
C38 voutn d6b 1.03899f
C39 d1b voutp 0.19083f
C40 voutn voutp 36.3519f
C41 voutn d5b 0.71931f
C42 d0 a_3600_6224# 0.01825f
C43 vb d2b 0
C44 vb d7b 0
C45 d7 voutp 1.74668f
C46 d6b d6 0.38436f
C47 d4b voutp 0.21014f
C48 a_30700_9584# voutn 1.36458f
C49 voutn a_19200_7792# 0.52252f
C50 a_3600_6224# voutn 0.37238f
C51 voutn a_24400_9584# 0.68956f
C52 a_8800_6448# d1b 0.54761f
C53 a_8800_6448# voutn 0.38397f
C54 voutn a_39200_10780# 2.58391f
C55 vb d0b 0
C56 vb d6b 0
C57 a_14000_6896# voutn 0.41819f
C58 voutn a_52100_11736# 5.11436f
C59 voutp d6 1.10581f
C60 d3b voutp 0.20201f
C61 d4b a_24400_9584# 0.60698f
C62 vb voutp 2.98918f
C63 vb d5b 0
C64 d7 a_52100_11736# 0.51316f
C65 d3b a_19200_7792# 0.57452f
C66 d2 d2b 0.37999f
C67 d4 d4b 0.38234f
C68 d6 a_39200_10780# 0.26463f
C69 a_30700_9584# vb 2.526f
C70 vb a_19200_7792# 0.85446f
C71 a_3600_6224# vb 0.63175f
C72 vb a_24400_9584# 1.39768f
C73 a_8800_6448# vb 0.66612f
C74 vb a_39200_10780# 4.74056f
C75 d5 voutp 0.78613f
C76 d5 d5b 0.38283f
C77 a_14000_6896# vb 0.72924f
C78 vb a_52100_11736# 9.16899f
C79 d5 a_30700_9584# 0.14111f
C80 d2 voutp 0.47804f
C81 d3 d3b 0.38077f
C82 voutn d1b 0.40233f
C83 d1 vss 3.29464f
C84 d0 vss 3.29136f
C85 d2 vss 3.30046f
C86 d3 vss 3.31218f
C87 d5 vss 3.74285f
C88 d4 vss 3.32428f
C89 d6 vss 4.74402f
C90 voutp vss 85.9502f
C91 d7 vss 6.7557f
C92 d0b vss 5.52673f
C93 d1b vss 5.63268f
C94 d2b vss 5.84378f
C95 d3b vss 6.26634f
C96 d5b vss 7.46029f
C97 d4b vss 7.09992f
C98 d6b vss 8.97805f
C99 voutn vss 79.88558f
C100 d7b vss 11.33529f
C101 vb vss 0.1474p
C102 a_30700_9584# vss 16.5327f
C103 a_3600_6224# vss 4.83273f
C104 a_8800_6448# vss 5.17161f
C105 a_14000_6896# vss 5.79662f
C106 a_19200_7792# vss 7.07737f
C107 a_24400_9584# vss 10.4305f
C108 a_39200_10780# vss 28.2444f
C109 a_52100_11736# vss 51.1721f
C110 vb.t0 vss 0.35917f
C111 vb.t1 vss 0.35767f
C112 vb.n0 vss 0.50602f
C113 vb.t2 vss 0.35767f
C114 vb.n1 vss 0.25733f
C115 vb.t3 vss 0.35767f
C116 vb.n2 vss 0.25733f
C117 vb.t4 vss 0.35767f
C118 vb.n3 vss 0.25733f
C119 vb.t5 vss 0.35767f
C120 vb.n4 vss 0.25733f
C121 vb.t6 vss 0.35767f
C122 vb.n5 vss 0.25733f
C123 vb.t7 vss 0.35767f
C124 vb.n6 vss 0.25733f
C125 vb.t8 vss 0.35767f
C126 vb.n7 vss 0.25733f
C127 vb.t9 vss 0.35767f
C128 vb.n8 vss 0.25733f
C129 vb.t10 vss 0.35767f
C130 vb.n9 vss 0.25733f
C131 vb.t11 vss 0.35767f
C132 vb.n10 vss 0.25733f
C133 vb.t12 vss 0.35767f
C134 vb.n11 vss 0.25733f
C135 vb.t13 vss 0.35767f
C136 vb.n12 vss 0.25733f
C137 vb.t14 vss 0.35767f
C138 vb.n13 vss 0.25733f
C139 vb.t15 vss 0.35767f
C140 vb.n14 vss 2.29974f
C141 vb.t16 vss 0.35917f
C142 vb.t17 vss 0.35767f
C143 vb.n15 vss 0.50602f
C144 vb.t18 vss 0.35767f
C145 vb.n16 vss 0.25733f
C146 vb.t19 vss 0.35767f
C147 vb.n17 vss 0.25733f
C148 vb.t20 vss 0.35767f
C149 vb.n18 vss 0.25733f
C150 vb.t21 vss 0.35767f
C151 vb.n19 vss 0.25733f
C152 vb.t22 vss 0.35767f
C153 vb.n20 vss 0.25733f
C154 vb.t23 vss 0.35767f
C155 vb.n21 vss 1.08272f
C156 vb.n22 vss 11.6847f
C157 vb.t24 vss 0.35917f
C158 vb.t25 vss 0.35767f
C159 vb.n23 vss 0.50602f
C160 vb.t26 vss 0.35767f
C161 vb.n24 vss 0.25733f
C162 vb.t27 vss 0.35767f
C163 vb.n25 vss 1.15539f
C164 vb.n26 vss 3.10721f
C165 vb.t28 vss 0.35917f
C166 vb.t29 vss 0.35767f
C167 vb.n27 vss 1.40408f
C168 vb.n28 vss 2.59551f
C169 vb.t30 vss 0.53913f
C170 vb.n29 vss 3.62329f
C171 vb.t31 vss 0.45199f
C172 vb.n30 vss 3.61947f
C173 vb.t32 vss 0.42955f
C174 vb.n31 vss 3.59643f
C175 vb.t33 vss 0.42788f
C176 vb.n32 vss 2.9241f
C177 d7b.t0 vss 0.14384f
C178 d7b.t1 vss 0.14338f
C179 d7b.n0 vss 0.52411f
C180 d7b.t2 vss 0.14338f
C181 d7b.n1 vss 0.26814f
C182 d7b.t3 vss 0.14338f
C183 d7b.n2 vss 0.26814f
C184 d7b.t4 vss 0.14341f
C185 d7b.n3 vss 0.66467f
C186 voutn.t13 vss 1.3923f
C187 voutn.t12 vss 1.36764f
C188 voutn.n0 vss 0.60391f
C189 voutn.t10 vss 1.36764f
C190 voutn.n1 vss 0.30148f
C191 voutn.t6 vss 1.36764f
C192 voutn.n2 vss 0.30148f
C193 voutn.t11 vss 1.36798f
C194 voutn.n3 vss 4.18552f
C195 voutn.t4 vss 1.15831f
C196 voutn.t3 vss 1.13389f
C197 voutn.n4 vss 0.59442f
C198 voutn.t2 vss 1.13437f
C199 voutn.n5 vss 2.11615f
C200 voutn.n6 vss 21.6667f
C201 voutn.t9 vss 0.86722f
C202 voutn.t8 vss 0.84337f
C203 voutn.n7 vss 2.46798f
C204 voutn.n8 vss 5.76663f
C205 voutn.t0 vss 2.44677f
C206 voutn.n9 vss 5.46645f
C207 voutn.t14 vss 2.03976f
C208 voutn.n10 vss 5.33323f
C209 voutn.t1 vss 1.73357f
C210 voutn.n11 vss 5.51506f
C211 voutn.t7 vss 1.44503f
C212 voutn.n12 vss 5.74523f
C213 voutn.t5 vss 1.12005f
C214 voutn.n13 vss 4.79015f
C215 d6b.t0 vss 0.12396f
C216 d6b.t1 vss 0.12346f
C217 d6b.n0 vss 0.51479f
C218 d6b.t2 vss 0.12349f
C219 d6b.n1 vss 0.63582f
C220 d4b.t0 vss 0.12045f
C221 d5b.t0 vss 0.10179f
C222 d5b.t1 vss 0.1012f
C223 d5b.n0 vss 0.87301f
C224 d3b.t0 vss 0.09317f
C225 d2b.t0 vss 0.07833f
C226 d1b.t0 vss 0.07105f
C227 d0b.t0 vss 0.06751f
C228 d7.t0 vss 0.15144f
C229 d7.t1 vss 0.15096f
C230 d7.n0 vss 0.5518f
C231 d7.t2 vss 0.15096f
C232 d7.n1 vss 0.2823f
C233 d7.t3 vss 0.15096f
C234 d7.n2 vss 0.2823f
C235 d7.t4 vss 0.15099f
C236 d7.n3 vss 0.5441f
C237 voutp.t7 vss 0.8689f
C238 voutp.t0 vss 0.85351f
C239 voutp.n0 vss 0.37689f
C240 voutp.t1 vss 0.85351f
C241 voutp.n1 vss 0.18815f
C242 voutp.t6 vss 0.85351f
C243 voutp.n2 vss 0.18815f
C244 voutp.t8 vss 0.85372f
C245 voutp.n3 vss 2.83943f
C246 voutp.t14 vss 0.72287f
C247 voutp.t13 vss 0.70763f
C248 voutp.n4 vss 0.37096f
C249 voutp.t12 vss 0.70793f
C250 voutp.n5 vss 1.59331f
C251 voutp.n6 vss 14.3364f
C252 voutp.t10 vss 0.54121f
C253 voutp.t9 vss 0.52632f
C254 voutp.n7 vss 1.77281f
C255 voutp.n8 vss 3.83739f
C256 voutp.t11 vss 1.7242f
C257 voutp.n9 vss 3.68543f
C258 voutp.t5 vss 1.41705f
C259 voutp.n10 vss 3.52873f
C260 voutp.t4 vss 1.19514f
C261 voutp.n11 vss 3.60967f
C262 voutp.t2 vss 0.99383f
C263 voutp.n12 vss 3.74287f
C264 voutp.t3 vss 0.77161f
C265 voutp.n13 vss 3.08253f
C266 d6.t0 vss 0.13417f
C267 d6.t1 vss 0.13363f
C268 d6.n0 vss 0.55717f
C269 d6.t2 vss 0.13366f
C270 d6.n1 vss 0.55711f
C271 d4.t0 vss 0.1315f
C272 d5.t0 vss 0.10972f
C273 d5.t1 vss 0.10908f
C274 d5.n0 vss 0.84238f
C275 d3.t0 vss 0.08996f
C276 d2.t0 vss 0.07026f
C277 d0.t0 vss 0.05712f
C278 d1.t0 vss 0.0613f
.ends
