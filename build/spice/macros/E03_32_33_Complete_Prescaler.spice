* E03_32_33_Complete_Prescaler: LVS reference of GDS cell E03_32_33_Complete_Prescaler (from M_prescaler.spice, subckt M_prescaler)
* NGSPICE file created from M_prescaler.ext - technology: gf180mcuE

.subckt E03_32_33_Complete_Prescaler CLK_IN Q2 X1_N1 X2_N1 Q3 X3_N1 X5_N1 X4_N1 MC NOR_OUT Q4b Q3n
+ Q5b CLK_OUT X1_N2 X2_N2 X3_N2 Q1 X6_DYN NOR_PSTACK X5_N2 X4_N2 VDD VSS
X0 NOR_PSTACK Q1 VDD VDD pfet_03v3 ad=0.728p pd=3.54u as=0.728p ps=3.54u w=1.12u l=0.28u
X1 VDD X3_N1 Q4b VDD pfet_03v3 ad=0.728p pd=3.54u as=0.728p ps=3.54u w=1.12u l=0.28u
X2 X1_N2 NOR_OUT VSS VSS nfet_03v3 ad=0.3416p pd=2.34u as=0.3416p ps=2.34u w=0.56u l=0.28u
X3 Q4b Q3 a_8936_412# VSS nfet_03v3 ad=0.3416p pd=2.34u as=0.1456p ps=1.08u w=0.56u l=0.28u
X4 a_4346_3028# Q4b a_4346_2860# VSS nfet_03v3 ad=93.59999f pd=0.88u as=93.59999f ps=0.88u w=0.36u l=0.32u
X5 VSS Q4b a_8188_3004# VSS nfet_03v3 ad=0.3416p pd=2.34u as=0.1456p ps=1.08u w=0.56u l=0.28u
X6 VDD X2_N1 Q3n VDD pfet_03v3 ad=0.728p pd=3.54u as=0.728p ps=3.54u w=1.12u l=0.28u
X7 Q3n CLK_IN a_6398_412# VSS nfet_03v3 ad=0.3416p pd=2.34u as=0.1456p ps=1.08u w=0.56u l=0.28u
X8 VSS X5_N1 a_5388_2996# VSS nfet_03v3 ad=0.3416p pd=2.34u as=0.1456p ps=1.08u w=0.56u l=0.28u
X9 X2_N1 X2_N2 a_5798_404# VSS nfet_03v3 ad=0.3416p pd=2.34u as=0.1456p ps=1.08u w=0.56u l=0.28u
X10 X3_N2 Q4b VSS VSS nfet_03v3 ad=0.3416p pd=2.34u as=0.3416p ps=2.34u w=0.56u l=0.28u
X11 a_8336_404# Q3 VSS VSS nfet_03v3 ad=0.1456p pd=1.08u as=0.3416p ps=2.34u w=0.56u l=0.28u
X12 VDD Q3n Q3 VDD pfet_03v3 ad=0.728p pd=3.54u as=0.728p ps=3.54u w=1.12u l=0.28u
X13 a_7674_1144# Q3 X3_N2 VDD pfet_03v3 ad=0.2912p pd=1.64u as=0.728p ps=3.54u w=1.12u l=0.28u
X14 X2_N2 Q2 VSS VSS nfet_03v3 ad=0.3416p pd=2.34u as=0.3416p ps=2.34u w=0.56u l=0.28u
X15 a_4298_412# X1_N1 VSS VSS nfet_03v3 ad=0.1456p pd=1.08u as=0.3416p ps=2.34u w=0.56u l=0.28u
X16 a_4346_3364# CLK_OUT a_4346_3196# VSS nfet_03v3 ad=93.59999f pd=0.88u as=93.59999f ps=0.88u w=0.36u l=0.32u
X17 a_5136_1144# CLK_IN X2_N2 VDD pfet_03v3 ad=0.2912p pd=1.64u as=0.728p ps=3.54u w=1.12u l=0.28u
X18 a_3698_404# CLK_IN VSS VSS nfet_03v3 ad=0.1456p pd=1.08u as=0.3416p ps=2.34u w=0.56u l=0.28u
X19 VSS CLK_OUT X5_N2 VSS nfet_03v3 ad=0.3416p pd=2.34u as=0.3416p ps=2.34u w=0.56u l=0.28u
X20 VDD NOR_OUT a_3036_1144# VDD pfet_03v3 ad=0.728p pd=3.54u as=0.2912p ps=1.64u w=1.12u l=0.28u
X21 VSS Q3n NOR_OUT VSS nfet_03v3 ad=0.3416p pd=2.34u as=0.3416p ps=2.34u w=0.56u l=0.28u
X22 X5_N2 Q5b a_6538_2264# VDD pfet_03v3 ad=0.728p pd=3.54u as=0.2912p ps=1.64u w=1.12u l=0.28u
X23 a_8936_412# X3_N1 VSS VSS nfet_03v3 ad=0.1456p pd=1.08u as=0.3416p ps=2.34u w=0.56u l=0.28u
X24 VSS Q5b a_5988_3004# VSS nfet_03v3 ad=0.3416p pd=2.34u as=0.1456p ps=1.08u w=0.56u l=0.28u
X25 a_4346_2860# CLK_IN a_4346_2692# VSS nfet_03v3 ad=93.59999f pd=0.88u as=93.59999f ps=0.88u w=0.36u l=0.32u
X26 a_8188_3004# X4_N2 X4_N1 VSS nfet_03v3 ad=0.1456p pd=1.08u as=0.3416p ps=2.34u w=0.56u l=0.28u
X27 X6_DYN Q3n a_4311_1994# VDD pfet_03v3 ad=0.468p pd=2.74u as=0.1872p ps=1.24u w=0.72u l=0.32u
X28 VSS Q1 NOR_OUT VSS nfet_03v3 ad=0.3416p pd=2.34u as=0.3416p ps=2.34u w=0.56u l=0.28u
X29 VSS X4_N1 a_7588_2996# VSS nfet_03v3 ad=0.3416p pd=2.34u as=0.1456p ps=1.08u w=0.56u l=0.28u
X30 a_5388_2996# Q5b CLK_OUT VSS nfet_03v3 ad=0.1456p pd=1.08u as=0.3416p ps=2.34u w=0.56u l=0.28u
X31 NOR_OUT Q3n NOR_PSTACK VDD pfet_03v3 ad=0.728p pd=3.54u as=0.728p ps=3.54u w=1.12u l=0.28u
X32 VDD CLK_IN X2_N1 VDD pfet_03v3 ad=0.728p pd=3.54u as=0.728p ps=3.54u w=1.12u l=0.28u
X33 a_6398_412# X2_N1 VSS VSS nfet_03v3 ad=0.1456p pd=1.08u as=0.3416p ps=2.34u w=0.56u l=0.28u
X34 a_3826_2864# X6_DYN Q1 VSS nfet_03v3 ad=93.59999f pd=0.88u as=0.228p ps=1.98u w=0.36u l=0.36u
X35 a_5798_404# CLK_IN VSS VSS nfet_03v3 ad=0.1456p pd=1.08u as=0.3416p ps=2.34u w=0.56u l=0.28u
X36 a_4346_2692# Q3n X6_DYN VSS nfet_03v3 ad=93.59999f pd=0.88u as=0.228p ps=1.98u w=0.36u l=0.32u
X37 a_6538_2264# CLK_OUT VDD VDD pfet_03v3 ad=0.2912p pd=1.64u as=0.728p ps=3.54u w=1.12u l=0.28u
X38 VDD X1_N1 Q2 VDD pfet_03v3 ad=0.728p pd=3.54u as=0.728p ps=3.54u w=1.12u l=0.28u
X39 Q1 X6_DYN VDD VDD pfet_03v3 ad=0.2432p pd=2.06u as=0.2432p ps=2.06u w=0.36u l=0.36u
X40 X4_N1 Q4b VDD VDD pfet_03v3 ad=0.728p pd=3.54u as=0.728p ps=3.54u w=1.12u l=0.28u
X41 CLK_OUT X5_N1 VDD VDD pfet_03v3 ad=0.728p pd=3.54u as=0.728p ps=3.54u w=1.12u l=0.28u
X42 a_4346_3196# Q5b a_4346_3028# VSS nfet_03v3 ad=93.59999f pd=0.88u as=93.59999f ps=0.88u w=0.36u l=0.32u
X43 VSS Q5b X4_N2 VSS nfet_03v3 ad=0.3416p pd=2.34u as=0.3416p ps=2.34u w=0.56u l=0.28u
X44 X4_N2 Q4b a_8738_2264# VDD pfet_03v3 ad=0.728p pd=3.54u as=0.2912p ps=1.64u w=1.12u l=0.28u
X45 a_3036_1144# CLK_IN X1_N2 VDD pfet_03v3 ad=0.2912p pd=1.64u as=0.728p ps=3.54u w=1.12u l=0.28u
X46 VDD Q3 X3_N1 VDD pfet_03v3 ad=0.728p pd=3.54u as=0.728p ps=3.54u w=1.12u l=0.28u
X47 a_5988_3004# X5_N2 X5_N1 VSS nfet_03v3 ad=0.1456p pd=1.08u as=0.3416p ps=2.34u w=0.56u l=0.28u
X48 X3_N1 X3_N2 a_8336_404# VSS nfet_03v3 ad=0.3416p pd=2.34u as=0.1456p ps=1.08u w=0.56u l=0.28u
X49 a_7588_2996# Q4b Q5b VSS nfet_03v3 ad=0.1456p pd=1.08u as=0.3416p ps=2.34u w=0.56u l=0.28u
X50 a_4311_1994# CLK_IN VDD VDD pfet_03v3 ad=0.1872p pd=1.24u as=0.468p ps=2.74u w=0.72u l=0.32u
X51 VSS CLK_IN a_3826_2864# VSS nfet_03v3 ad=0.228p pd=1.98u as=93.59999f ps=0.88u w=0.36u l=0.36u
X52 VDD Q4b a_7674_1144# VDD pfet_03v3 ad=0.728p pd=3.54u as=0.2912p ps=1.64u w=1.12u l=0.28u
X53 VSS MC a_4346_3364# VSS nfet_03v3 ad=0.228p pd=1.98u as=93.59999f ps=0.88u w=0.36u l=0.32u
X54 X5_N1 Q5b VDD VDD pfet_03v3 ad=0.728p pd=3.54u as=0.728p ps=3.54u w=1.12u l=0.28u
X55 a_8738_2264# Q5b VDD VDD pfet_03v3 ad=0.2912p pd=1.64u as=0.728p ps=3.54u w=1.12u l=0.28u
X56 VDD CLK_IN X1_N1 VDD pfet_03v3 ad=0.728p pd=3.54u as=0.728p ps=3.54u w=1.12u l=0.28u
X57 Q2 CLK_IN a_4298_412# VSS nfet_03v3 ad=0.3416p pd=2.34u as=0.1456p ps=1.08u w=0.56u l=0.28u
X58 Q3 Q3n VSS VSS nfet_03v3 ad=0.3416p pd=2.34u as=0.3416p ps=2.34u w=0.56u l=0.28u
X59 Q5b X4_N1 VDD VDD pfet_03v3 ad=0.728p pd=3.54u as=0.728p ps=3.54u w=1.12u l=0.28u
X60 VDD Q2 a_5136_1144# VDD pfet_03v3 ad=0.728p pd=3.54u as=0.2912p ps=1.64u w=1.12u l=0.28u
X61 X1_N1 X1_N2 a_3698_404# VSS nfet_03v3 ad=0.3416p pd=2.34u as=0.1456p ps=1.08u w=0.56u l=0.28u
.ends E03_32_33_Complete_Prescaler
