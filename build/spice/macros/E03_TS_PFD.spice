* E03_TS_PFD: LVS reference of GDS cell E03_TS_PFD (from ts_pfd_all.spice, subckt TS_PFD)
** sch_path: /foss/designs/Tri_State_Phase_Detector/SR_Flipflop.sch
.subckt E03_SR_FlipFlop 3v3 D set CLK_In CLK_Out CLK_Outb reset vss net3 net5 net8
*.iopin D
*.iopin CLK_In
*.iopin 3v3
*.iopin vss
*.iopin set
*.iopin reset
*.iopin CLK_Out
*.iopin CLK_Outb
XM8 CLK_Out CLK_Outb vss vss nfet_03v3 L=0.28u W=0.56u nf=1 ad='int((nf+1)/2) * W/nf * 0.18u' as='int((nf+2)/2) * W/nf * 0.18u' pd='2*int((nf+1)/2) * (W/nf + 0.18u)'
+ ps='2*int((nf+2)/2) * (W/nf + 0.18u)' nrd='0.18u / W' nrs='0.18u / W' sa=0 sb=0 sd=0
XM9 CLK_Out CLK_Outb 3v3 3v3 pfet_03v3 L=0.28u W=1.12u nf=1 ad='int((nf+1)/2) * W/nf * 0.18u' as='int((nf+2)/2) * W/nf * 0.18u' pd='2*int((nf+1)/2) * (W/nf + 0.18u)'
+ ps='2*int((nf+2)/2) * (W/nf + 0.18u)' nrd='0.18u / W' nrs='0.18u / W' sa=0 sb=0 sd=0
XM1 net1 set 3v3 3v3 pfet_03v3 L=0.28u W=1.12u nf=1 ad='int((nf+1)/2) * W/nf * 0.18u' as='int((nf+2)/2) * W/nf * 0.18u' pd='2*int((nf+1)/2) * (W/nf + 0.18u)'
+ ps='2*int((nf+2)/2) * (W/nf + 0.18u)' nrd='0.18u / W' nrs='0.18u / W' sa=0 sb=0 sd=0
XM2 net2 D net1 3v3 pfet_03v3 L=0.28u W=1.12u nf=1 ad='int((nf+1)/2) * W/nf * 0.18u' as='int((nf+2)/2) * W/nf * 0.18u' pd='2*int((nf+1)/2) * (W/nf + 0.18u)'
+ ps='2*int((nf+2)/2) * (W/nf + 0.18u)' nrd='0.18u / W' nrs='0.18u / W' sa=0 sb=0 sd=0
XM3 net3 CLK_In net2 3v3 pfet_03v3 L=0.28u W=1.12u nf=1 ad='int((nf+1)/2) * W/nf * 0.18u' as='int((nf+2)/2) * W/nf * 0.18u' pd='2*int((nf+1)/2) * (W/nf + 0.18u)'
+ ps='2*int((nf+2)/2) * (W/nf + 0.18u)' nrd='0.18u / W' nrs='0.18u / W' sa=0 sb=0 sd=0
XM4 net3 D vss vss nfet_03v3 L=0.28u W=0.56u nf=1 ad='int((nf+1)/2) * W/nf * 0.18u' as='int((nf+2)/2) * W/nf * 0.18u' pd='2*int((nf+1)/2) * (W/nf + 0.18u)'
+ ps='2*int((nf+2)/2) * (W/nf + 0.18u)' nrd='0.18u / W' nrs='0.18u / W' sa=0 sb=0 sd=0
XM5 net3 set vss vss nfet_03v3 L=0.28u W=0.56u nf=1 ad='int((nf+1)/2) * W/nf * 0.18u' as='int((nf+2)/2) * W/nf * 0.18u' pd='2*int((nf+1)/2) * (W/nf + 0.18u)'
+ ps='2*int((nf+2)/2) * (W/nf + 0.18u)' nrd='0.18u / W' nrs='0.18u / W' sa=0 sb=0 sd=0
XM6 net4 CLK_In 3v3 3v3 pfet_03v3 L=0.28u W=1.12u nf=1 ad='int((nf+1)/2) * W/nf * 0.18u' as='int((nf+2)/2) * W/nf * 0.18u' pd='2*int((nf+1)/2) * (W/nf + 0.18u)'
+ ps='2*int((nf+2)/2) * (W/nf + 0.18u)' nrd='0.18u / W' nrs='0.18u / W' sa=0 sb=0 sd=0
XM7 net5 reset net4 3v3 pfet_03v3 L=0.28u W=1.12u nf=1 ad='int((nf+1)/2) * W/nf * 0.18u' as='int((nf+2)/2) * W/nf * 0.18u' pd='2*int((nf+1)/2) * (W/nf + 0.18u)'
+ ps='2*int((nf+2)/2) * (W/nf + 0.18u)' nrd='0.18u / W' nrs='0.18u / W' sa=0 sb=0 sd=0
XM10 net5 net8 3v3 3v3 pfet_03v3 L=0.28u W=1.12u nf=1 ad='int((nf+1)/2) * W/nf * 0.18u' as='int((nf+2)/2) * W/nf * 0.18u' pd='2*int((nf+1)/2) * (W/nf + 0.18u)'
+ ps='2*int((nf+2)/2) * (W/nf + 0.18u)' nrd='0.18u / W' nrs='0.18u / W' sa=0 sb=0 sd=0
XM11 net5 net3 net6 vss nfet_03v3 L=0.28u W=0.56u nf=1 ad='int((nf+1)/2) * W/nf * 0.18u' as='int((nf+2)/2) * W/nf * 0.18u' pd='2*int((nf+1)/2) * (W/nf + 0.18u)'
+ ps='2*int((nf+2)/2) * (W/nf + 0.18u)' nrd='0.18u / W' nrs='0.18u / W' sa=0 sb=0 sd=0
XM12 net6 CLK_In vss vss nfet_03v3 L=0.28u W=0.56u nf=1 ad='int((nf+1)/2) * W/nf * 0.18u' as='int((nf+2)/2) * W/nf * 0.18u' pd='2*int((nf+1)/2) * (W/nf + 0.18u)'
+ ps='2*int((nf+2)/2) * (W/nf + 0.18u)' nrd='0.18u / W' nrs='0.18u / W' sa=0 sb=0 sd=0
XM13 net5 reset vss vss nfet_03v3 L=0.28u W=0.56u nf=1 ad='int((nf+1)/2) * W/nf * 0.18u' as='int((nf+2)/2) * W/nf * 0.18u' pd='2*int((nf+1)/2) * (W/nf + 0.18u)'
+ ps='2*int((nf+2)/2) * (W/nf + 0.18u)' nrd='0.18u / W' nrs='0.18u / W' sa=0 sb=0 sd=0
XM14 CLK_Outb net5 3v3 3v3 pfet_03v3 L=0.28u W=1.12u nf=1 ad='int((nf+1)/2) * W/nf * 0.18u' as='int((nf+2)/2) * W/nf * 0.18u' pd='2*int((nf+1)/2) * (W/nf + 0.18u)'
+ ps='2*int((nf+2)/2) * (W/nf + 0.18u)' nrd='0.18u / W' nrs='0.18u / W' sa=0 sb=0 sd=0
XM15 CLK_Outb CLK_In net7 vss nfet_03v3 L=0.28u W=0.56u nf=1 ad='int((nf+1)/2) * W/nf * 0.18u' as='int((nf+2)/2) * W/nf * 0.18u' pd='2*int((nf+1)/2) * (W/nf + 0.18u)'
+ ps='2*int((nf+2)/2) * (W/nf + 0.18u)' nrd='0.18u / W' nrs='0.18u / W' sa=0 sb=0 sd=0
XM16 net7 net5 vss vss nfet_03v3 L=0.28u W=0.56u nf=1 ad='int((nf+1)/2) * W/nf * 0.18u' as='int((nf+2)/2) * W/nf * 0.18u' pd='2*int((nf+1)/2) * (W/nf + 0.18u)'
+ ps='2*int((nf+2)/2) * (W/nf + 0.18u)' nrd='0.18u / W' nrs='0.18u / W' sa=0 sb=0 sd=0
XM17 net8 set vss vss nfet_03v3 L=0.28u W=0.56u nf=1 ad='int((nf+1)/2) * W/nf * 0.18u' as='int((nf+2)/2) * W/nf * 0.18u' pd='2*int((nf+1)/2) * (W/nf + 0.18u)'
+ ps='2*int((nf+2)/2) * (W/nf + 0.18u)' nrd='0.18u / W' nrs='0.18u / W' sa=0 sb=0 sd=0
XM18 net8 set 3v3 3v3 pfet_03v3 L=0.28u W=1.12u nf=1 ad='int((nf+1)/2) * W/nf * 0.18u' as='int((nf+2)/2) * W/nf * 0.18u' pd='2*int((nf+1)/2) * (W/nf + 0.18u)'
+ ps='2*int((nf+2)/2) * (W/nf + 0.18u)' nrd='0.18u / W' nrs='0.18u / W' sa=0 sb=0 sd=0
XM19 CLK_Outb set vss vss nfet_03v3 L=0.28u W=0.56u nf=1 ad='int((nf+1)/2) * W/nf * 0.18u' as='int((nf+2)/2) * W/nf * 0.18u' pd='2*int((nf+1)/2) * (W/nf + 0.18u)'
+ ps='2*int((nf+2)/2) * (W/nf + 0.18u)' nrd='0.18u / W' nrs='0.18u / W' sa=0 sb=0 sd=0
.ends E03_TS_PFD
.end

** sch_path: /foss/designs/Tri_State_Phase_Detector/R_Flipflop.sch
.subckt E03_R_FlipFlop D CLK_In 3v3 vss reset CLK_Out CLK_Outb net2 net5
*.iopin D
*.iopin CLK_In
*.iopin 3v3
*.iopin vss
*.iopin reset
*.iopin CLK_Out
*.iopin CLK_Outb
XM8 CLK_Out CLK_Outb vss vss nfet_03v3 L=0.36u W=0.36u nf=1 ad='int((nf+1)/2) * W/nf * 0.18u' as='int((nf+2)/2) * W/nf * 0.18u' pd='2*int((nf+1)/2) * (W/nf + 0.18u)'
+ ps='2*int((nf+2)/2) * (W/nf + 0.18u)' nrd='0.18u / W' nrs='0.18u / W' sa=0 sb=0 sd=0
XM9 CLK_Out CLK_Outb 3v3 3v3 pfet_03v3 L=0.36u W=0.72u nf=1 ad='int((nf+1)/2) * W/nf * 0.18u' as='int((nf+2)/2) * W/nf * 0.18u' pd='2*int((nf+1)/2) * (W/nf + 0.18u)'
+ ps='2*int((nf+2)/2) * (W/nf + 0.18u)' nrd='0.18u / W' nrs='0.18u / W' sa=0 sb=0 sd=0
XM1 net1 D 3v3 3v3 pfet_03v3 L=0.36u W=0.72u nf=1 ad='int((nf+1)/2) * W/nf * 0.18u' as='int((nf+2)/2) * W/nf * 0.18u' pd='2*int((nf+1)/2) * (W/nf + 0.18u)'
+ ps='2*int((nf+2)/2) * (W/nf + 0.18u)' nrd='0.18u / W' nrs='0.18u / W' sa=0 sb=0 sd=0
XM2 net2 CLK_In net1 3v3 pfet_03v3 L=0.36u W=0.72u nf=1 ad='int((nf+1)/2) * W/nf * 0.18u' as='int((nf+2)/2) * W/nf * 0.18u' pd='2*int((nf+1)/2) * (W/nf + 0.18u)'
+ ps='2*int((nf+2)/2) * (W/nf + 0.18u)' nrd='0.18u / W' nrs='0.18u / W' sa=0 sb=0 sd=0
XM3 net2 D vss vss nfet_03v3 L=0.36u W=0.36u nf=1 ad='int((nf+1)/2) * W/nf * 0.18u' as='int((nf+2)/2) * W/nf * 0.18u' pd='2*int((nf+1)/2) * (W/nf + 0.18u)'
+ ps='2*int((nf+2)/2) * (W/nf + 0.18u)' nrd='0.18u / W' nrs='0.18u / W' sa=0 sb=0 sd=0
XM4 net3 CLK_In 3v3 3v3 pfet_03v3 L=0.36u W=0.72u nf=1 ad='int((nf+1)/2) * W/nf * 0.18u' as='int((nf+2)/2) * W/nf * 0.18u' pd='2*int((nf+1)/2) * (W/nf + 0.18u)'
+ ps='2*int((nf+2)/2) * (W/nf + 0.18u)' nrd='0.18u / W' nrs='0.18u / W' sa=0 sb=0 sd=0
XM5 net5 reset net3 3v3 pfet_03v3 L=0.36u W=0.72u nf=1 ad='int((nf+1)/2) * W/nf * 0.18u' as='int((nf+2)/2) * W/nf * 0.18u' pd='2*int((nf+1)/2) * (W/nf + 0.18u)'
+ ps='2*int((nf+2)/2) * (W/nf + 0.18u)' nrd='0.18u / W' nrs='0.18u / W' sa=0 sb=0 sd=0
XM6 net5 net2 net4 vss nfet_03v3 L=0.36u W=0.36u nf=1 ad='int((nf+1)/2) * W/nf * 0.18u' as='int((nf+2)/2) * W/nf * 0.18u' pd='2*int((nf+1)/2) * (W/nf + 0.18u)'
+ ps='2*int((nf+2)/2) * (W/nf + 0.18u)' nrd='0.18u / W' nrs='0.18u / W' sa=0 sb=0 sd=0
XM7 net4 CLK_In vss vss nfet_03v3 L=0.36u W=0.36u nf=1 ad='int((nf+1)/2) * W/nf * 0.18u' as='int((nf+2)/2) * W/nf * 0.18u' pd='2*int((nf+1)/2) * (W/nf + 0.18u)'
+ ps='2*int((nf+2)/2) * (W/nf + 0.18u)' nrd='0.18u / W' nrs='0.18u / W' sa=0 sb=0 sd=0
XM10 net5 reset vss vss nfet_03v3 L=0.36u W=0.36u nf=1 ad='int((nf+1)/2) * W/nf * 0.18u' as='int((nf+2)/2) * W/nf * 0.18u' pd='2*int((nf+1)/2) * (W/nf + 0.18u)'
+ ps='2*int((nf+2)/2) * (W/nf + 0.18u)' nrd='0.18u / W' nrs='0.18u / W' sa=0 sb=0 sd=0
XM11 CLK_Outb net5 net6 vss nfet_03v3 L=0.36u W=0.36u nf=1 ad='int((nf+1)/2) * W/nf * 0.18u' as='int((nf+2)/2) * W/nf * 0.18u' pd='2*int((nf+1)/2) * (W/nf + 0.18u)'
+ ps='2*int((nf+2)/2) * (W/nf + 0.18u)' nrd='0.18u / W' nrs='0.18u / W' sa=0 sb=0 sd=0
XM12 net6 CLK_In vss vss nfet_03v3 L=0.36u W=0.36u nf=1 ad='int((nf+1)/2) * W/nf * 0.18u' as='int((nf+2)/2) * W/nf * 0.18u' pd='2*int((nf+1)/2) * (W/nf + 0.18u)'
+ ps='2*int((nf+2)/2) * (W/nf + 0.18u)' nrd='0.18u / W' nrs='0.18u / W' sa=0 sb=0 sd=0
XM13 CLK_Outb net5 3v3 3v3 pfet_03v3 L=0.36u W=0.72u nf=1 ad='int((nf+1)/2) * W/nf * 0.18u' as='int((nf+2)/2) * W/nf * 0.18u' pd='2*int((nf+1)/2) * (W/nf + 0.18u)'
+ ps='2*int((nf+2)/2) * (W/nf + 0.18u)' nrd='0.18u / W' nrs='0.18u / W' sa=0 sb=0 sd=0
.ends E03_TS_PFD
.end

.subckt E03_2_Input_And A B Y nand_out 3v3 vss
XM1 nand_out A 3v3 3v3 pfet_03v3 L=0.28u W=1.12u
XM2 nand_out B 3v3 3v3 pfet_03v3 L=0.28u W=1.12u
XM3 nand_out B mid vss nfet_03v3 L=0.28u W=0.56u
XM4 mid A vss vss nfet_03v3 L=0.28u W=0.56u
XM5 Y nand_out 3v3 3v3 pfet_03v3 L=0.28u W=1.12u
XM6 Y nand_out vss vss nfet_03v3 L=0.28u W=0.56u
.ends E03_TS_PFD
.subckt E03_2_Input_And_Inv_Input A B Y A_b nand_out 3v3 vss
XM1 A_b A 3v3 3v3 pfet_03v3 L=0.28u W=1.12u
XM2 A_b A vss vss nfet_03v3 L=0.28u W=0.56u
XM3 nand_out A_b 3v3 3v3 pfet_03v3 L=0.28u W=1.12u
XM4 nand_out B 3v3 3v3 pfet_03v3 L=0.28u W=1.12u
XM5 nand_out B mid vss nfet_03v3 L=0.28u W=0.56u
XM6 mid A_b vss vss nfet_03v3 L=0.28u W=0.56u
XM7 Y nand_out 3v3 3v3 pfet_03v3 L=0.28u W=1.12u
XM8 Y nand_out vss vss nfet_03v3 L=0.28u W=0.56u
.ends E03_TS_PFD
.subckt E03_2_Input_Or A B Y nor_out 3v3 vss
XM1 mid B 3v3 3v3 pfet_03v3 L=0.28u W=1.12u
XM2 nor_out A mid 3v3 pfet_03v3 L=0.28u W=1.12u
XM3 nor_out A vss vss nfet_03v3 L=0.28u W=0.56u
XM4 nor_out B vss vss nfet_03v3 L=0.28u W=0.56u
XM5 Y nor_out 3v3 3v3 pfet_03v3 L=0.28u W=1.12u
XM6 Y nor_out vss vss nfet_03v3 L=0.28u W=0.56u
.ends E03_TS_PFD
* Three-state PFD (Centurelli et al., Fig. 4) from the fixed cells - LVS reference

.subckt E03_TS_PFD R V UP UPB DN 3v3 vss
* E03_SR_FlipFlop 3v3 D set CLK_In CLK_Out CLK_Outb reset vss net3 net5 net8
XFF1 3v3 3v3 SR R UP UPq RS vss a3 a5 a8 E03_SR_FlipFlop
XFF2 3v3 3v3 SV V DN DNq RS vss b3 b5 b8 E03_SR_FlipFlop
* E03_R_FlipFlop D CLK_In 3v3 vss reset CLK_Out CLK_Outb net2 net5
XFF3 FZR R 3v3 vss SR ER ERb c2 c5 E03_R_FlipFlop
XFF4 FZV V 3v3 vss SV EV EVb d2 d5 E03_R_FlipFlop
XRS UP DN RS rsn 3v3 vss E03_2_Input_And
XFZR UP RS FZR fzrn 3v3 vss E03_2_Input_Or
XFZV DN RS FZV fzvn 3v3 vss E03_2_Input_Or
XSR FZR ER SR sra srn 3v3 vss E03_2_Input_And_Inv_Input
XSV FZV EV SV sva svn 3v3 vss E03_2_Input_And_Inv_Input
XUPB UP 3v3 UPB upa upn 3v3 vss E03_2_Input_And_Inv_Input
.ends E03_TS_PFD
