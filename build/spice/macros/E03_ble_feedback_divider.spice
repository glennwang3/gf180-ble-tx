* E03_ble_feedback_divider: LVS reference of GDS cell E03_ble_feedback_divider (from M_divider.spice, subckt M_divider)
* NGSPICE file created from M_divider.ext - technology: gf180mcuE

.subckt E03_ble_feedback_divider VDD VSS cfg_divider[0] cfg_divider[3] cfg_divider[4] cfg_divider[5]
+ clk_feedback clk_prescaled modulus_33 cfg_divider[1] cfg_divider[2] rst_n
X0 a_5164_7909# a_1096_6296# a_4956_7909# VSS nfet_05v0 ad=0.2119p pd=1.335u as=0.4137p ps=1.9u w=0.815u l=0.6u
X1 a_1548_4765# a_2000_6296# a_2112_5176# VDD pfet_05v0 ad=0.3159p pd=1.735u as=0.44955p ps=1.955u w=1.215u l=0.5u
X2 a_1806_10260# a_1096_6296# VSS VSS nfet_05v0 ad=0.1469p pd=1.085u as=0.2486p ps=2.01u w=0.565u l=0.6u
X3 a_2920_4476# a_708_4472# a_1980_4032# VDD pfet_05v0 ad=0.25375p pd=1.51u as=0.2424p ps=1.465u w=0.505u l=0.5u
X4 VSS a_5500_6324# a_7639_6362# VSS nfet_05v0 ad=0.1209p pd=0.985u as=0.2046p ps=1.81u w=0.465u l=0.6u
X5 VDD a_8300_5079# a_8212_5176# VDD pfet_05v0 ad=0.5368p pd=3.32u as=0.5368p ps=3.32u w=1.22u l=1u
X6 a_7336_9476# cfg_divider[2] a_7336_9880# VDD pfet_05v0 ad=0.3172p pd=1.74u as=0.3172p ps=1.74u w=1.22u l=0.5u
X7 a_8076_9783# a_7988_9880# VSS VSS nfet_05v0 ad=0.3608p pd=2.52u as=0.3608p ps=2.52u w=0.82u l=1u
X8 a_4800_3292# a_2276_3287# a_4488_3292# VSS nfet_05v0 ad=94.5f pd=0.885u as=0.2007p ps=1.475u w=0.36u l=0.6u
X9 a_3337_4336# a_2176_4292# VDD VDD pfet_05v0 ad=0.26p pd=1.52u as=0.29465p ps=1.74u w=1u l=0.5u
X10 VDD a_9084_7080# a_8996_7124# VDD pfet_05v0 ad=0.5368p pd=3.32u as=0.5368p ps=3.32u w=1.22u l=1u
X11 a_7000_2908# a_6160_2491# a_6712_2508# VSS nfet_05v0 ad=43.2f pd=0.6u as=93.59999f ps=0.88u w=0.36u l=0.6u
X12 a_2176_4292# a_3673_2768# VDD VDD pfet_05v0 ad=0.5346p pd=3.31u as=0.5346p ps=3.31u w=1.215u l=0.5u
X13 a_3036_3608# a_2936_3438# VDD VDD pfet_05v0 ad=0.2028p pd=1.3u as=0.3432p ps=2.44u w=0.78u l=0.5u
X14 a_7924_8312# a_5457_9456# a_7736_8312# VDD pfet_05v0 ad=0.3172p pd=1.74u as=0.5368p ps=3.32u w=1.22u l=0.5u
X15 a_4905_3248# a_2176_4292# VDD VDD pfet_05v0 ad=0.26p pd=1.52u as=0.29465p ps=1.74u w=1u l=0.5u
X16 a_3256_7996# a_1044_7991# a_2316_8263# VDD pfet_05v0 ad=0.25375p pd=1.51u as=0.2424p ps=1.465u w=0.505u l=0.5u
X17 a_7168_2908# a_7020_2464# a_7000_2908# VSS nfet_05v0 ad=43.2f pd=0.6u as=43.2f ps=0.6u w=0.36u l=0.6u
X18 a_6508_8780# a_6408_8736# VSS VSS nfet_05v0 ad=93.59999f pd=0.88u as=0.1584p ps=1.6u w=0.36u l=0.6u
X19 VSS a_796_1675# a_708_1719# VSS nfet_05v0 ad=0.1053p pd=0.925u as=0.1782p ps=1.69u w=0.405u l=0.6u
X20 VDD a_8251_7552# a_7759_7125# VDD pfet_05v0 ad=0.3718p pd=2.57u as=0.2197p ps=1.365u w=0.845u l=0.5u
X21 a_9084_1943# a_8996_2040# VSS VSS nfet_05v0 ad=0.3608p pd=2.52u as=0.3608p ps=2.52u w=0.82u l=1u
X22 VDD a_796_1675# a_708_4472# VDD pfet_05v0 ad=0.2249p pd=1.385u as=0.3806p ps=2.61u w=0.865u l=0.5u
X23 VDD clk_prescaled a_3696_5556# VDD pfet_05v0 ad=0.428p pd=2.02u as=0.2542p ps=1.44u w=0.82u l=0.5u
X24 a_1484_6340# a_1364_6296# a_1216_6340# VSS nfet_05v0 ad=0.1312p pd=1.14u as=0.2569p ps=1.56u w=0.82u l=0.6u
X25 a_5185_9432# a_2744_10700# a_5577_10011# VDD pfet_05v0 ad=0.2486p pd=2.01u as=0.1469p ps=1.085u w=0.565u l=0.5u
X26 VSS a_7759_7125# a_7868_4772# VSS nfet_05v0 ad=0.3608p pd=2.52u as=0.1312p ps=1.14u w=0.82u l=0.6u
X27 a_796_5512# a_708_5556# VSS VSS nfet_05v0 ad=0.3608p pd=2.52u as=0.3608p ps=2.52u w=0.82u l=1u
X28 a_4156_6647# a_4068_6744# VSS VSS nfet_05v0 ad=0.3608p pd=2.52u as=0.3608p ps=2.52u w=0.82u l=1u
X29 a_5164_8337# a_2744_10700# VDD VDD pfet_05v0 ad=0.2847p pd=1.615u as=0.5913p ps=3.27u w=1.095u l=0.5u
X30 VSS a_2176_4292# a_3696_3292# VSS nfet_05v0 ad=0.2016p pd=1.48u as=43.2f ps=0.6u w=0.36u l=0.6u
X31 VSS a_1020_7552# a_2116_9544# VSS nfet_05v0 ad=0.2112p pd=1.84u as=0.1248p ps=1u w=0.48u l=0.6u
X32 a_3568_7996# a_1456_8312# a_3256_7996# VDD pfet_05v0 ad=0.1313p pd=1.025u as=0.25375p ps=1.51u w=0.505u l=0.5u
X33 a_1246_5176# a_1324_4765# VSS VSS nfet_05v0 ad=0.1469p pd=1.085u as=0.2486p ps=2.01u w=0.565u l=0.6u
X34 a_2444_4728# a_5724_6324# a_5600_6744# VDD pfet_05v0 ad=0.5368p pd=3.32u as=0.3782p ps=1.84u w=1.22u l=0.5u
X35 VDD a_1244_8648# a_1156_8692# VDD pfet_05v0 ad=0.5368p pd=3.32u as=0.5368p ps=3.32u w=1.22u l=1u
X36 a_6272_4059# a_5860_4472# VDD VDD pfet_05v0 ad=0.3806p pd=2.61u as=0.2249p ps=1.385u w=0.865u l=0.5u
X37 VDD a_1244_5512# a_1156_5556# VDD pfet_05v0 ad=0.5368p pd=3.32u as=0.5368p ps=3.32u w=1.22u l=1u
X38 VDD a_6396_10216# a_6308_10260# VDD pfet_05v0 ad=0.5368p pd=3.32u as=0.5368p ps=3.32u w=1.22u l=1u
X39 a_8753_2908# a_2176_4292# VSS VSS nfet_05v0 ad=0.134p pd=1.1u as=0.1224p ps=1.04u w=0.36u l=0.6u
X40 VDD a_6844_1943# a_6756_2040# VDD pfet_05v0 ad=0.5368p pd=3.32u as=0.5368p ps=3.32u w=1.22u l=1u
X41 VDD a_8412_10216# a_8324_10260# VDD pfet_05v0 ad=0.5368p pd=3.32u as=0.5368p ps=3.32u w=1.22u l=1u
X42 a_3561_7472# a_3144_7612# a_3937_7612# VSS nfet_05v0 ad=0.176p pd=1.68u as=0.134p ps=1.1u w=0.4u l=0.6u
X43 a_1692_7212# a_1216_6340# VDD VDD pfet_05v0 ad=0.2028p pd=1.3u as=0.3432p ps=2.44u w=0.78u l=0.5u
X44 a_6628_5176# a_4604_4495# VDD VDD pfet_05v0 ad=0.3172p pd=1.74u as=0.5368p ps=3.32u w=1.22u l=0.5u
X45 VDD a_1096_6296# a_2372_5556# VDD pfet_05v0 ad=0.4005p pd=2.12u as=0.1456p ps=1.08u w=0.56u l=0.5u
X46 VDD a_2632_9502# a_1020_7552# VDD pfet_05v0 ad=0.3782p pd=1.84u as=0.3782p ps=1.84u w=1.22u l=0.5u
X47 a_8272_9180# a_6160_8763# a_7960_9180# VDD pfet_05v0 ad=0.1313p pd=1.025u as=0.25375p ps=1.51u w=0.505u l=0.5u
X48 a_3036_3608# a_2936_3438# VSS VSS nfet_05v0 ad=93.59999f pd=0.88u as=0.1584p ps=1.6u w=0.36u l=0.6u
X49 a_8272_2908# a_6160_2491# a_7960_2908# VDD pfet_05v0 ad=0.1313p pd=1.025u as=0.25375p ps=1.51u w=0.505u l=0.5u
X50 VDD a_1244_10216# a_1156_10260# VDD pfet_05v0 ad=0.5368p pd=3.32u as=0.5368p ps=3.32u w=1.22u l=1u
X51 a_7000_9180# a_6160_8763# a_6712_8780# VSS nfet_05v0 ad=43.2f pd=0.6u as=93.59999f ps=0.88u w=0.36u l=0.6u
X52 a_1980_1991# a_1672_2040# VDD VDD pfet_05v0 ad=0.2424p pd=1.465u as=0.2222p ps=1.89u w=0.505u l=0.5u
X53 VDD a_1692_3511# a_1604_3608# VDD pfet_05v0 ad=0.5368p pd=3.32u as=0.5368p ps=3.32u w=1.22u l=1u
X54 a_3337_4336# a_2920_4476# a_3713_4476# VSS nfet_05v0 ad=0.176p pd=1.68u as=0.134p ps=1.1u w=0.4u l=0.6u
X55 a_7168_9180# a_7020_8736# a_7000_9180# VSS nfet_05v0 ad=43.2f pd=0.6u as=43.2f ps=0.6u w=0.36u l=0.6u
X56 VSS a_2176_4292# a_3024_9180# VSS nfet_05v0 ad=0.2016p pd=1.48u as=43.2f ps=0.6u w=0.36u l=0.6u
X57 VDD cfg_divider[1] a_6516_8444# VDD pfet_05v0 ad=0.4005p pd=2.12u as=0.1456p ps=1.08u w=0.56u l=0.5u
X58 a_1120_2040# a_708_1719# VDD VDD pfet_05v0 ad=0.3806p pd=2.61u as=0.2249p ps=1.385u w=0.865u l=0.5u
X59 VDD a_8860_10216# a_8772_10260# VDD pfet_05v0 ad=0.5368p pd=3.32u as=0.5368p ps=3.32u w=1.22u l=1u
X60 VSS a_2176_4292# a_2464_7996# VSS nfet_05v0 ad=0.2016p pd=1.48u as=43.2f ps=0.6u w=0.36u l=0.6u
X61 a_1896_7212# a_932_7608# a_1692_7212# VSS nfet_05v0 ad=93.59999f pd=0.88u as=93.59999f ps=0.88u w=0.36u l=0.6u
X62 a_4716_10216# a_4628_10260# VSS VSS nfet_05v0 ad=0.3608p pd=2.52u as=0.3608p ps=2.52u w=0.82u l=1u
X63 a_1434_9880# a_1324_4765# a_1246_9880# VDD pfet_05v0 ad=0.4087p pd=1.89u as=0.5368p ps=3.32u w=1.22u l=0.5u
X64 a_5164_5512# a_5076_5556# VSS VSS nfet_05v0 ad=0.3608p pd=2.52u as=0.3608p ps=2.52u w=0.82u l=1u
X65 VDD a_3816_9180# a_4233_9040# VDD pfet_05v0 ad=0.44p pd=2.88u as=0.26p ps=1.52u w=1u l=0.5u
X66 a_3584_9743# a_3696_5556# VDD VDD pfet_05v0 ad=0.3782p pd=1.84u as=0.428p ps=2.02u w=1.22u l=0.5u
X67 VDD a_1324_4765# a_6308_6744# VDD pfet_05v0 ad=0.5346p pd=3.31u as=0.44955p ps=1.955u w=1.215u l=0.5u
X68 a_3337_1680# a_2920_1724# a_3713_1724# VSS nfet_05v0 ad=0.176p pd=1.68u as=0.134p ps=1.1u w=0.4u l=0.6u
X69 VDD a_3548_3559# a_3444_3608# VDD pfet_05v0 ad=0.45p pd=2.02u as=0.2028p ps=1.3u w=0.78u l=0.5u
X70 VDD cfg_divider[0] a_7825_5512# VDD pfet_05v0 ad=0.5368p pd=3.32u as=0.5368p ps=3.32u w=1.22u l=0.5u
X71 VDD a_1980_1991# a_1876_2040# VDD pfet_05v0 ad=0.45p pd=2.02u as=0.2028p ps=1.3u w=0.78u l=0.5u
X72 VDD a_5500_1943# a_5412_2040# VDD pfet_05v0 ad=0.5368p pd=3.32u as=0.5368p ps=3.32u w=1.22u l=1u
X73 a_8753_9180# a_2176_4292# VSS VSS nfet_05v0 ad=0.134p pd=1.1u as=0.1224p ps=1.04u w=0.36u l=0.6u
X74 VSS a_8232_7864# a_7924_8312# VSS nfet_05v0 ad=0.218p pd=1.52u as=0.2132p ps=1.34u w=0.82u l=0.6u
X75 a_1468_2040# a_1345_3608# VDD VDD pfet_05v0 ad=0.2028p pd=1.3u as=0.3432p ps=2.44u w=0.78u l=0.5u
X76 a_2444_4728# a_5500_6324# VSS VSS nfet_05v0 ad=93.59999f pd=0.88u as=93.59999f ps=0.88u w=0.36u l=0.6u
X77 a_5508_7564# a_1096_6296# a_6336_7124# VDD pfet_05v0 ad=0.2464p pd=2u as=0.196p ps=1.26u w=0.56u l=0.5u
X78 a_2472_10260# a_2744_10700# a_2264_8736# VDD pfet_05v0 ad=0.3172p pd=1.74u as=0.3172p ps=1.74u w=1.22u l=0.5u
X79 a_8524_3511# a_8436_3608# VSS VSS nfet_05v0 ad=0.3608p pd=2.52u as=0.3608p ps=2.52u w=0.82u l=1u
X80 a_8879_6875# a_7825_5512# a_8691_6875# VDD pfet_05v0 ad=0.1469p pd=1.085u as=0.2486p ps=2.01u w=0.565u l=0.5u
X81 a_796_3511# a_708_3608# VSS VSS nfet_05v0 ad=0.3608p pd=2.52u as=0.3608p ps=2.52u w=0.82u l=1u
X82 VSS a_1096_6296# a_2184_5556# VSS nfet_05v0 ad=0.218p pd=1.52u as=93.59999f ps=0.88u w=0.36u l=0.6u
X83 a_3240_3608# a_2688_3608# a_3036_3608# VDD pfet_05v0 ad=0.2028p pd=1.3u as=0.2028p ps=1.3u w=0.78u l=0.5u
X84 a_3696_3292# a_3548_3559# a_3528_3292# VSS nfet_05v0 ad=43.2f pd=0.6u as=43.2f ps=0.6u w=0.36u l=0.6u
X85 a_3673_7952# a_2176_4292# VDD VDD pfet_05v0 ad=0.26p pd=1.52u as=0.29465p ps=1.74u w=1u l=0.5u
X86 VDD a_3337_4336# a_3232_4476# VDD pfet_05v0 ad=0.29465p pd=1.74u as=0.1313p ps=1.025u w=0.505u l=0.5u
X87 a_2212_2508# rst_n VDD VDD pfet_05v0 ad=0.3432p pd=2.44u as=0.45p ps=2.02u w=0.78u l=0.5u
X88 a_3260_6647# a_3172_6744# VSS VSS nfet_05v0 ad=0.3608p pd=2.52u as=0.3608p ps=2.52u w=0.82u l=1u
X89 a_4828_3944# a_4905_3248# VDD VDD pfet_05v0 ad=0.5346p pd=3.31u as=0.5346p ps=3.31u w=1.215u l=0.5u
X90 VSS a_1324_4765# a_1484_6340# VSS nfet_05v0 ad=0.3608p pd=2.52u as=0.1312p ps=1.14u w=0.82u l=0.6u
X91 VDD a_5612_5512# a_5524_5556# VDD pfet_05v0 ad=0.5368p pd=3.32u as=0.5368p ps=3.32u w=1.22u l=1u
X92 a_7960_2908# a_6160_2491# a_7020_2464# VSS nfet_05v0 ad=0.2007p pd=1.475u as=0.2007p ps=1.475u w=0.36u l=0.6u
X93 VSS a_2968_10216# a_2264_8736# VSS nfet_05v0 ad=0.218p pd=1.52u as=0.2132p ps=1.34u w=0.82u l=0.6u
X94 a_2920_1724# a_708_1719# a_1980_1991# VDD pfet_05v0 ad=0.25375p pd=1.51u as=0.2424p ps=1.465u w=0.505u l=0.5u
X95 a_8860_5512# a_8772_5556# VSS VSS nfet_05v0 ad=0.3608p pd=2.52u as=0.3608p ps=2.52u w=0.82u l=1u
X96 a_3696_5556# clk_prescaled VDD VDD pfet_05v0 ad=0.2542p pd=1.44u as=0.3608p ps=2.52u w=0.82u l=0.5u
X97 a_1912_6744# a_1096_6296# a_1548_9469# VDD pfet_05v0 ad=0.3172p pd=1.74u as=0.3172p ps=1.74u w=1.22u l=0.5u
X98 a_7945_6040# a_7825_5512# a_7721_6040# VSS nfet_05v0 ad=0.1304p pd=1.135u as=0.2119p ps=1.335u w=0.815u l=0.6u
X99 VDD a_1980_4032# a_1876_4076# VDD pfet_05v0 ad=0.45p pd=2.02u as=0.2028p ps=1.3u w=0.78u l=0.5u
X100 VSS cfg_divider[5] a_1364_6296# VSS nfet_05v0 ad=0.2112p pd=1.84u as=0.2112p ps=1.84u w=0.48u l=0.6u
X101 VDD a_8636_1943# a_8548_2040# VDD pfet_05v0 ad=0.5368p pd=3.32u as=0.5368p ps=3.32u w=1.22u l=1u
X102 VDD a_8072_4476# a_8489_4336# VDD pfet_05v0 ad=0.44p pd=2.88u as=0.26p ps=1.52u w=1u l=0.5u
X103 a_8972_3511# a_8884_3608# VSS VSS nfet_05v0 ad=0.3608p pd=2.52u as=0.3608p ps=2.52u w=0.82u l=1u
X104 a_1468_4076# a_1246_5176# VDD VDD pfet_05v0 ad=0.2028p pd=1.3u as=0.3432p ps=2.44u w=0.78u l=0.5u
X105 a_5600_6744# a_5500_6324# a_5376_6744# VDD pfet_05v0 ad=0.3782p pd=1.84u as=0.3782p ps=1.84u w=1.22u l=0.5u
X106 VSS a_2176_4292# a_2352_7612# VSS nfet_05v0 ad=0.2016p pd=1.48u as=43.2f ps=0.6u w=0.36u l=0.6u
X107 VSS a_8489_4336# a_8384_4476# VSS nfet_05v0 ad=0.1224p pd=1.04u as=94.5f ps=0.885u w=0.36u l=0.6u
X108 a_2464_7996# a_2316_8263# a_2296_7996# VSS nfet_05v0 ad=43.2f pd=0.6u as=43.2f ps=0.6u w=0.36u l=0.6u
X109 VDD a_1020_7552# a_932_7608# VDD pfet_05v0 ad=0.2249p pd=1.385u as=0.3806p ps=2.61u w=0.865u l=0.5u
X110 a_2316_2464# a_2008_2508# VSS VSS nfet_05v0 ad=0.2007p pd=1.475u as=0.2016p ps=1.48u w=0.36u l=0.6u
X111 a_4828_3944# a_4905_3248# VSS VSS nfet_05v0 ad=0.3586p pd=2.51u as=0.3586p ps=2.51u w=0.815u l=0.6u
X112 a_7639_6362# a_7924_8312# VSS VSS nfet_05v0 ad=0.21175p pd=1.41u as=0.1209p ps=0.985u w=0.465u l=0.6u
X113 VDD a_3820_10216# a_3732_10260# VDD pfet_05v0 ad=0.5368p pd=3.32u as=0.5368p ps=3.32u w=1.22u l=1u
X114 VSS a_2000_6296# a_7224_7908# VSS nfet_05v0 ad=0.3608p pd=2.52u as=0.1312p ps=1.14u w=0.82u l=0.6u
X115 a_1672_4076# a_708_4472# a_1468_4076# VSS nfet_05v0 ad=93.59999f pd=0.88u as=93.59999f ps=0.88u w=0.36u l=0.6u
X116 a_6516_6340# a_4956_7909# VSS VSS nfet_05v0 ad=0.1312p pd=1.14u as=0.3608p ps=2.52u w=0.82u l=0.6u
X117 a_2568_8780# a_2016_8763# a_2364_8780# VDD pfet_05v0 ad=0.2028p pd=1.3u as=0.2028p ps=1.3u w=0.78u l=0.5u
X118 a_1020_7552# a_2632_9502# VDD VDD pfet_05v0 ad=0.3782p pd=1.84u as=0.5368p ps=3.32u w=1.22u l=0.5u
X119 a_7960_9180# a_6160_8763# a_7020_8736# VSS nfet_05v0 ad=0.2007p pd=1.475u as=0.2007p ps=1.475u w=0.36u l=0.6u
X120 a_2212_8312# a_2176_4292# VDD VDD pfet_05v0 ad=0.3432p pd=2.44u as=0.45p ps=2.02u w=0.78u l=0.5u
X121 VDD a_9196_5079# a_9108_5176# VDD pfet_05v0 ad=0.5368p pd=3.32u as=0.5368p ps=3.32u w=1.22u l=1u
X122 VDD a_4828_3944# a_5724_6324# VDD pfet_05v0 ad=0.5368p pd=3.32u as=0.5368p ps=3.32u w=1.22u l=0.5u
X123 a_1096_6296# a_3561_7472# VDD VDD pfet_05v0 ad=0.5346p pd=3.31u as=0.5346p ps=3.31u w=1.215u l=0.5u
X124 VDD a_4156_9783# a_4068_9880# VDD pfet_05v0 ad=0.5368p pd=3.32u as=0.5368p ps=3.32u w=1.22u l=1u
X125 VDD a_4156_6647# a_4068_6744# VDD pfet_05v0 ad=0.5368p pd=3.32u as=0.5368p ps=3.32u w=1.22u l=1u
X126 a_1216_6340# a_1364_6296# a_1216_6744# VDD pfet_05v0 ad=0.3159p pd=1.735u as=0.44955p ps=1.955u w=1.215u l=0.5u
X127 a_2016_8763# a_1604_9176# VSS VSS nfet_05v0 ad=0.1782p pd=1.69u as=0.1053p ps=0.925u w=0.405u l=0.6u
X128 a_5500_6324# a_8377_2768# VSS VSS nfet_05v0 ad=0.3586p pd=2.51u as=0.3586p ps=2.51u w=0.815u l=0.6u
X129 a_2788_6876# a_1096_6296# VDD VDD pfet_05v0 ad=0.1456p pd=1.08u as=0.4005p ps=2.12u w=0.56u l=0.5u
X130 VSS a_1806_10260# a_2968_10216# VSS nfet_05v0 ad=0.1584p pd=1.6u as=93.59999f ps=0.88u w=0.36u l=0.6u
X131 VDD a_1020_7552# a_1604_9176# VDD pfet_05v0 ad=0.2249p pd=1.385u as=0.3806p ps=2.61u w=0.865u l=0.5u
X132 VDD a_2632_9502# a_1020_7552# VDD pfet_05v0 ad=0.428p pd=2.02u as=0.3782p ps=1.84u w=1.22u l=0.5u
X133 a_5432_4472# a_4828_3944# a_5208_4472# VSS nfet_05v0 ad=0.1312p pd=1.14u as=0.2132p ps=1.34u w=0.82u l=0.6u
X134 a_2968_10216# a_1806_10260# a_3348_10260# VDD pfet_05v0 ad=0.2464p pd=2u as=0.1456p ps=1.08u w=0.56u l=0.5u
X135 a_6404_6054# a_4604_4495# VSS VSS nfet_05v0 ad=0.1469p pd=1.085u as=0.2486p ps=2.01u w=0.565u l=0.6u
X136 a_2000_6296# a_3673_7952# VSS VSS nfet_05v0 ad=0.3586p pd=2.51u as=0.3586p ps=2.51u w=0.815u l=0.6u
X137 a_1672_2040# a_708_1719# a_1468_2040# VSS nfet_05v0 ad=93.59999f pd=0.88u as=93.59999f ps=0.88u w=0.36u l=0.6u
X138 VSS a_2856_6040# a_2444_4728# VSS nfet_05v0 ad=93.59999f pd=0.88u as=93.59999f ps=0.88u w=0.36u l=0.6u
X139 a_8232_7864# cfg_divider[3] VSS VSS nfet_05v0 ad=93.59999f pd=0.88u as=0.218p ps=1.52u w=0.36u l=0.6u
X140 a_6160_2491# a_5748_2904# VSS VSS nfet_05v0 ad=0.1782p pd=1.69u as=0.1053p ps=0.925u w=0.405u l=0.6u
X141 VSS a_2856_4798# a_796_1675# VSS nfet_05v0 ad=0.1183p pd=0.975u as=0.1183p ps=0.975u w=0.455u l=0.6u
X142 a_7964_10216# a_7876_10260# VSS VSS nfet_05v0 ad=0.3608p pd=2.52u as=0.3608p ps=2.52u w=0.82u l=1u
X143 a_2184_5556# cfg_divider[5] VSS VSS nfet_05v0 ad=93.59999f pd=0.88u as=0.1584p ps=1.6u w=0.36u l=0.6u
X144 a_2632_9502# a_3584_9743# VDD VDD pfet_05v0 ad=0.2542p pd=1.44u as=0.428p ps=2.02u w=0.82u l=0.5u
X145 VDD a_2920_1724# a_3337_1680# VDD pfet_05v0 ad=0.44p pd=2.88u as=0.26p ps=1.52u w=1u l=0.5u
X146 VDD modulus_33 a_7748_4728# VDD pfet_05v0 ad=0.5368p pd=3.32u as=0.5368p ps=3.32u w=1.22u l=0.5u
X147 a_3232_4476# a_708_4472# a_2920_4476# VSS nfet_05v0 ad=94.5f pd=0.885u as=0.2007p ps=1.475u w=0.36u l=0.6u
X148 a_5457_9456# a_8377_9040# VDD VDD pfet_05v0 ad=0.5346p pd=3.31u as=0.5346p ps=3.31u w=1.215u l=0.5u
X149 a_2296_7996# a_1456_8312# a_2008_8312# VSS nfet_05v0 ad=43.2f pd=0.6u as=93.59999f ps=0.88u w=0.36u l=0.6u
X150 a_2352_7612# a_2204_7168# a_2184_7612# VSS nfet_05v0 ad=43.2f pd=0.6u as=43.2f ps=0.6u w=0.36u l=0.6u
X151 VDD a_3337_1680# a_3232_1724# VDD pfet_05v0 ad=0.29465p pd=1.74u as=0.1313p ps=1.025u w=0.505u l=0.5u
X152 VDD a_7740_1943# a_7652_2040# VDD pfet_05v0 ad=0.5368p pd=3.32u as=0.5368p ps=3.32u w=1.22u l=1u
X153 a_7329_5557# a_7601_5996# VDD VDD pfet_05v0 ad=0.3159p pd=1.735u as=0.3159p ps=1.735u w=1.215u l=0.5u
X154 VSS a_7336_9476# a_7412_10758# VSS nfet_05v0 ad=0.2486p pd=2.01u as=0.1469p ps=1.085u w=0.565u l=0.6u
X155 a_7132_4032# a_6824_4076# VDD VDD pfet_05v0 ad=0.2424p pd=1.465u as=0.2222p ps=1.89u w=0.505u l=0.5u
X156 a_7721_6040# a_7601_5996# a_7537_6040# VSS nfet_05v0 ad=0.2119p pd=1.335u as=0.1304p ps=1.135u w=0.815u l=0.6u
X157 a_4956_7909# a_1096_6296# a_5368_8337# VDD pfet_05v0 ad=0.4012p pd=1.85u as=0.58035p ps=2.155u w=1.095u l=0.5u
X158 VDD a_9308_5512# a_9220_5556# VDD pfet_05v0 ad=0.5368p pd=3.32u as=0.5368p ps=3.32u w=1.22u l=1u
X159 a_5376_6744# a_2856_6040# a_5172_6744# VDD pfet_05v0 ad=0.3782p pd=1.84u as=0.3172p ps=1.74u w=1.22u l=0.5u
X160 VDD a_796_9783# a_708_9880# VDD pfet_05v0 ad=0.5368p pd=3.32u as=0.5368p ps=3.32u w=1.22u l=1u
X161 VDD a_8524_9783# a_8436_9880# VDD pfet_05v0 ad=0.5368p pd=3.32u as=0.5368p ps=3.32u w=1.22u l=1u
X162 VDD a_8524_3511# a_8436_3608# VDD pfet_05v0 ad=0.5368p pd=3.32u as=0.5368p ps=3.32u w=1.22u l=1u
X163 a_7132_4032# a_6824_4076# VSS VSS nfet_05v0 ad=0.2007p pd=1.475u as=0.2016p ps=1.48u w=0.36u l=0.6u
X164 a_3144_7612# a_932_7608# a_2204_7168# VDD pfet_05v0 ad=0.25375p pd=1.51u as=0.2424p ps=1.465u w=0.505u l=0.5u
X165 a_3232_1724# a_708_1719# a_2920_1724# VSS nfet_05v0 ad=94.5f pd=0.885u as=0.2007p ps=1.475u w=0.36u l=0.6u
X166 VDD a_796_3511# a_708_3608# VDD pfet_05v0 ad=0.5368p pd=3.32u as=0.5368p ps=3.32u w=1.22u l=1u
X167 VDD a_6396_1943# a_6308_2040# VDD pfet_05v0 ad=0.5368p pd=3.32u as=0.5368p ps=3.32u w=1.22u l=1u
X168 a_6520_4032# a_1324_4765# VSS VSS nfet_05v0 ad=0.2569p pd=1.56u as=0.2244p ps=1.9u w=0.51u l=0.6u
X169 a_7336_9880# a_6664_10012# VDD VDD pfet_05v0 ad=0.3172p pd=1.74u as=0.4005p ps=2.12u w=1.22u l=0.5u
X170 VDD a_7960_9180# a_8377_9040# VDD pfet_05v0 ad=0.44p pd=2.88u as=0.26p ps=1.52u w=1u l=0.5u
X171 VDD a_3260_6647# a_3172_6744# VDD pfet_05v0 ad=0.5368p pd=3.32u as=0.5368p ps=3.32u w=1.22u l=1u
X172 a_2408_6296# a_1096_6296# VSS VSS nfet_05v0 ad=93.59999f pd=0.88u as=0.218p ps=1.52u w=0.36u l=0.6u
X173 a_3456_7612# a_1344_7195# a_3144_7612# VDD pfet_05v0 ad=0.1313p pd=1.025u as=0.25375p ps=1.51u w=0.505u l=0.5u
X174 a_7759_7125# a_7639_6362# VDD VDD pfet_05v0 ad=0.2197p pd=1.365u as=0.2197p ps=1.365u w=0.845u l=0.5u
X175 a_2856_6040# a_2184_5556# VSS VSS nfet_05v0 ad=0.2132p pd=1.34u as=0.218p ps=1.52u w=0.82u l=0.6u
X176 VDD a_796_8648# a_708_8692# VDD pfet_05v0 ad=0.5368p pd=3.32u as=0.5368p ps=3.32u w=1.22u l=1u
X177 a_4956_7909# a_2000_6296# a_5164_7909# VSS nfet_05v0 ad=0.4137p pd=1.9u as=0.2119p ps=1.335u w=0.815u l=0.6u
X178 VDD a_796_5512# a_708_5556# VDD pfet_05v0 ad=0.5368p pd=3.32u as=0.5368p ps=3.32u w=1.22u l=1u
X179 a_4488_3292# a_2688_3608# a_3548_3559# VSS nfet_05v0 ad=0.2007p pd=1.475u as=0.2007p ps=1.475u w=0.36u l=0.6u
X180 a_5208_4472# a_4536_3988# VSS VSS nfet_05v0 ad=0.2132p pd=1.34u as=0.218p ps=1.52u w=0.82u l=0.6u
X181 VDD a_4828_7080# a_4740_7124# VDD pfet_05v0 ad=0.5368p pd=3.32u as=0.5368p ps=3.32u w=1.22u l=1u
X182 a_3240_3608# a_2276_3287# a_3036_3608# VSS nfet_05v0 ad=93.59999f pd=0.88u as=93.59999f ps=0.88u w=0.36u l=0.6u
X183 VDD a_8972_9783# a_8884_9880# VDD pfet_05v0 ad=0.5368p pd=3.32u as=0.5368p ps=3.32u w=1.22u l=1u
X184 a_796_10216# a_708_10260# VSS VSS nfet_05v0 ad=0.3608p pd=2.52u as=0.3608p ps=2.52u w=0.82u l=1u
X185 VDD a_8972_3511# a_8884_3608# VDD pfet_05v0 ad=0.5368p pd=3.32u as=0.5368p ps=3.32u w=1.22u l=1u
X186 a_1020_7552# a_2632_9502# VDD VDD pfet_05v0 ad=0.3782p pd=1.84u as=0.3782p ps=1.84u w=1.22u l=0.5u
X187 VDD a_5052_1943# a_4964_2040# VDD pfet_05v0 ad=0.5368p pd=3.32u as=0.5368p ps=3.32u w=1.22u l=1u
X188 VSS a_796_1675# a_5860_4472# VSS nfet_05v0 ad=0.1053p pd=0.925u as=0.1782p ps=1.69u w=0.405u l=0.6u
X189 a_2968_10216# a_2744_10700# VSS VSS nfet_05v0 ad=93.59999f pd=0.88u as=0.218p ps=1.52u w=0.36u l=0.6u
X190 a_1994_10260# a_1096_6296# a_1806_10260# VDD pfet_05v0 ad=0.4087p pd=1.89u as=0.5368p ps=3.32u w=1.22u l=0.5u
X191 a_2184_7612# a_1344_7195# a_1896_7212# VSS nfet_05v0 ad=43.2f pd=0.6u as=93.59999f ps=0.88u w=0.36u l=0.6u
X192 VDD a_3673_2768# a_3568_2908# VDD pfet_05v0 ad=0.29465p pd=1.74u as=0.1313p ps=1.025u w=0.505u l=0.5u
X193 VDD cfg_divider[2] a_6852_10012# VDD pfet_05v0 ad=0.4005p pd=2.12u as=0.1456p ps=1.08u w=0.56u l=0.5u
X194 a_2444_4728# a_5052_6324# VSS VSS nfet_05v0 ad=93.59999f pd=0.88u as=0.1584p ps=1.6u w=0.36u l=0.6u
X195 VSS a_3673_2768# a_3568_2908# VSS nfet_05v0 ad=0.1224p pd=1.04u as=94.5f ps=0.885u w=0.36u l=0.6u
X196 a_4828_5079# a_4740_5176# VSS VSS nfet_05v0 ad=0.3608p pd=2.52u as=0.3608p ps=2.52u w=0.82u l=1u
X197 a_7392_10260# a_7000_7908# VDD VDD pfet_05v0 ad=0.4087p pd=1.89u as=0.5368p ps=3.32u w=1.22u l=0.5u
X198 a_1020_7552# a_2632_9502# VSS VSS nfet_05v0 ad=0.1183p pd=0.975u as=0.1183p ps=0.975u w=0.455u l=0.6u
X199 a_8489_4336# a_2176_4292# VDD VDD pfet_05v0 ad=0.26p pd=1.52u as=0.29465p ps=1.74u w=1u l=0.5u
X200 a_1960_4476# a_1120_4059# a_1672_4076# VSS nfet_05v0 ad=43.2f pd=0.6u as=93.59999f ps=0.88u w=0.36u l=0.6u
X201 VDD a_4268_10216# a_4180_10260# VDD pfet_05v0 ad=0.5368p pd=3.32u as=0.5368p ps=3.32u w=1.22u l=1u
X202 a_2128_4476# a_1980_4032# a_1960_4476# VSS nfet_05v0 ad=43.2f pd=0.6u as=43.2f ps=0.6u w=0.36u l=0.6u
X203 VDD a_1548_4765# a_1434_5176# VDD pfet_05v0 ad=0.5368p pd=3.32u as=0.4087p ps=1.89u w=1.22u l=0.5u
X204 a_6408_8736# a_4956_7909# a_6308_6744# VDD pfet_05v0 ad=0.3159p pd=1.735u as=0.5346p ps=3.31u w=1.215u l=0.5u
X205 a_6516_8444# a_2000_6296# a_6328_8444# VDD pfet_05v0 ad=0.1456p pd=1.08u as=0.2464p ps=2u w=0.56u l=0.5u
X206 a_7000_7908# cfg_divider[1] a_7000_8312# VDD pfet_05v0 ad=0.3172p pd=1.74u as=0.3172p ps=1.74u w=1.22u l=0.5u
X207 VDD a_5164_5512# a_5076_5556# VDD pfet_05v0 ad=0.5368p pd=3.32u as=0.5368p ps=3.32u w=1.22u l=1u
X208 VSS a_1548_9469# a_1246_9880# VSS nfet_05v0 ad=0.2486p pd=2.01u as=0.1469p ps=1.085u w=0.565u l=0.6u
X209 a_3256_7996# a_1456_8312# a_2316_8263# VSS nfet_05v0 ad=0.2007p pd=1.475u as=0.2007p ps=1.475u w=0.36u l=0.6u
X210 VSS a_1096_6296# a_5508_7564# VSS nfet_05v0 ad=0.1584p pd=1.6u as=0.126p ps=1.06u w=0.36u l=0.6u
X211 a_5612_10216# a_5524_10260# VSS VSS nfet_05v0 ad=0.3608p pd=2.52u as=0.3608p ps=2.52u w=0.82u l=1u
X212 a_1876_2040# a_708_1719# a_1672_2040# VDD pfet_05v0 ad=0.2028p pd=1.3u as=0.2028p ps=1.3u w=0.78u l=0.5u
X213 a_6712_8780# a_6160_8763# a_6508_8780# VDD pfet_05v0 ad=0.2028p pd=1.3u as=0.2028p ps=1.3u w=0.78u l=0.5u
X214 a_1804_2508# a_1704_2464# VDD VDD pfet_05v0 ad=0.2028p pd=1.3u as=0.3432p ps=2.44u w=0.78u l=0.5u
X215 a_1216_6340# a_1096_6296# VSS VSS nfet_05v0 ad=0.2569p pd=1.56u as=0.2244p ps=1.9u w=0.51u l=0.6u
X216 a_6712_2508# a_6160_2491# a_6508_2508# VDD pfet_05v0 ad=0.2028p pd=1.3u as=0.2028p ps=1.3u w=0.78u l=0.5u
X217 VDD a_796_1675# a_708_1719# VDD pfet_05v0 ad=0.2249p pd=1.385u as=0.3806p ps=2.61u w=0.865u l=0.5u
X218 a_1960_1724# a_1120_2040# a_1672_2040# VSS nfet_05v0 ad=43.2f pd=0.6u as=93.59999f ps=0.88u w=0.36u l=0.6u
X219 VDD a_8188_1943# a_8100_2040# VDD pfet_05v0 ad=0.5368p pd=3.32u as=0.5368p ps=3.32u w=1.22u l=1u
X220 a_2128_1724# a_1980_1991# a_1960_1724# VSS nfet_05v0 ad=43.2f pd=0.6u as=43.2f ps=0.6u w=0.36u l=0.6u
X221 a_3232_4476# a_1120_4059# a_2920_4476# VDD pfet_05v0 ad=0.1313p pd=1.025u as=0.25375p ps=1.51u w=0.505u l=0.5u
X222 VSS a_2000_6296# a_1806_10260# VSS nfet_05v0 ad=0.2486p pd=2.01u as=0.1469p ps=1.085u w=0.565u l=0.6u
X223 VDD a_1020_7552# a_5748_9176# VDD pfet_05v0 ad=0.2249p pd=1.385u as=0.3806p ps=2.61u w=0.865u l=0.5u
X224 a_6916_8780# a_2176_4292# VDD VDD pfet_05v0 ad=0.3432p pd=2.44u as=0.45p ps=2.02u w=0.78u l=0.5u
X225 a_6916_2508# a_2176_4292# VDD VDD pfet_05v0 ad=0.3432p pd=2.44u as=0.45p ps=2.02u w=0.78u l=0.5u
X226 a_8071_6744# cfg_divider[4] a_7639_6362# VDD pfet_05v0 ad=0.5346p pd=3.31u as=0.3159p ps=1.735u w=1.215u l=0.5u
X227 a_1456_8312# a_1044_7991# VDD VDD pfet_05v0 ad=0.3806p pd=2.61u as=0.2249p ps=1.385u w=0.865u l=0.5u
X228 VDD a_8860_5512# a_8772_5556# VDD pfet_05v0 ad=0.5368p pd=3.32u as=0.5368p ps=3.32u w=1.22u l=1u
X229 VDD a_4233_9040# a_4128_9180# VDD pfet_05v0 ad=0.29465p pd=1.74u as=0.1313p ps=1.025u w=0.505u l=0.5u
X230 VDD a_5208_4472# a_5130_2420# VDD pfet_05v0 ad=0.5368p pd=3.32u as=0.4087p ps=1.89u w=1.22u l=0.5u
X231 a_4233_9040# a_3816_9180# a_4609_9180# VSS nfet_05v0 ad=0.176p pd=1.68u as=0.134p ps=1.1u w=0.4u l=0.6u
X232 a_2100_7212# a_932_7608# a_1896_7212# VDD pfet_05v0 ad=0.2028p pd=1.3u as=0.2028p ps=1.3u w=0.78u l=0.5u
X233 VSS cfg_divider[4] a_7601_5996# VSS nfet_05v0 ad=0.2112p pd=1.84u as=0.2112p ps=1.84u w=0.48u l=0.6u
X234 a_1876_4076# a_708_4472# a_1672_4076# VDD pfet_05v0 ad=0.2028p pd=1.3u as=0.2028p ps=1.3u w=0.78u l=0.5u
X235 a_3584_9743# a_3696_5556# VSS VSS nfet_05v0 ad=0.1183p pd=0.975u as=0.1183p ps=0.975u w=0.455u l=0.6u
X236 VDD cfg_divider[4] a_7601_5996# VDD pfet_05v0 ad=0.5368p pd=3.32u as=0.5368p ps=3.32u w=1.22u l=0.5u
X237 a_5164_7909# a_2744_10700# a_4956_7909# VSS nfet_05v0 ad=0.2119p pd=1.335u as=0.3586p ps=2.51u w=0.815u l=0.6u
X238 VDD a_3256_2908# a_3673_2768# VDD pfet_05v0 ad=0.44p pd=2.88u as=0.26p ps=1.52u w=1u l=0.5u
X239 a_2688_3608# a_2276_3287# VSS VSS nfet_05v0 ad=0.1782p pd=1.69u as=0.1053p ps=0.925u w=0.405u l=0.6u
X240 a_6384_5556# a_4604_4495# VDD VDD pfet_05v0 ad=0.4087p pd=1.89u as=0.5368p ps=3.32u w=1.22u l=0.5u
X241 VSS a_4905_3248# a_4800_3292# VSS nfet_05v0 ad=0.1224p pd=1.04u as=94.5f ps=0.885u w=0.36u l=0.6u
X242 a_6392_3608# a_5500_6324# a_6408_2464# VDD pfet_05v0 ad=0.3172p pd=1.74u as=0.3172p ps=1.74u w=1.22u l=0.5u
X243 a_2316_2464# a_2008_2508# VDD VDD pfet_05v0 ad=0.2424p pd=1.465u as=0.2222p ps=1.89u w=0.505u l=0.5u
X244 a_7020_2464# a_6712_2508# VSS VSS nfet_05v0 ad=0.2007p pd=1.475u as=0.2016p ps=1.48u w=0.36u l=0.6u
X245 VDD a_8489_4336# a_8384_4476# VDD pfet_05v0 ad=0.29465p pd=1.74u as=0.1313p ps=1.025u w=0.505u l=0.5u
X246 VDD a_2876_8736# a_2772_8780# VDD pfet_05v0 ad=0.45p pd=2.02u as=0.2028p ps=1.3u w=0.78u l=0.5u
X247 VDD a_6844_10216# a_6756_10260# VDD pfet_05v0 ad=0.5368p pd=3.32u as=0.5368p ps=3.32u w=1.22u l=1u
X248 a_1804_8312# a_1246_9880# VDD VDD pfet_05v0 ad=0.2028p pd=1.3u as=0.3432p ps=2.44u w=0.78u l=0.5u
X249 a_7336_9476# a_6664_10012# VSS VSS nfet_05v0 ad=0.2132p pd=1.34u as=0.218p ps=1.52u w=0.82u l=0.6u
X250 a_8232_7864# a_5457_9456# a_8612_8444# VDD pfet_05v0 ad=0.2464p pd=2u as=0.1456p ps=1.08u w=0.56u l=0.5u
X251 a_3144_7612# a_1344_7195# a_2204_7168# VSS nfet_05v0 ad=0.2007p pd=1.475u as=0.2007p ps=1.475u w=0.36u l=0.6u
X252 a_3568_2908# a_1044_2904# a_3256_2908# VSS nfet_05v0 ad=94.5f pd=0.885u as=0.2007p ps=1.475u w=0.36u l=0.6u
X253 a_9084_7080# a_8996_7124# VSS VSS nfet_05v0 ad=0.3608p pd=2.52u as=0.3608p ps=2.52u w=0.82u l=1u
X254 VDD a_2316_2464# a_2212_2508# VDD pfet_05v0 ad=0.45p pd=2.02u as=0.2028p ps=1.3u w=0.78u l=0.5u
X255 a_4604_1943# a_4516_2040# VSS VSS nfet_05v0 ad=0.3608p pd=2.52u as=0.3608p ps=2.52u w=0.82u l=1u
X256 a_2920_4476# a_1120_4059# a_1980_4032# VSS nfet_05v0 ad=0.2007p pd=1.475u as=0.2007p ps=1.475u w=0.36u l=0.6u
X257 VSS a_2000_6296# a_2408_6296# VSS nfet_05v0 ad=0.1584p pd=1.6u as=93.59999f ps=0.88u w=0.36u l=0.6u
X258 VDD a_2000_6296# a_1994_10260# VDD pfet_05v0 ad=0.5368p pd=3.32u as=0.4087p ps=1.89u w=1.22u l=0.5u
X259 a_3080_6040# a_1096_6296# a_2856_6040# VSS nfet_05v0 ad=0.1312p pd=1.14u as=0.2132p ps=1.34u w=0.82u l=0.6u
X260 a_7028_4076# a_5860_4472# a_6824_4076# VDD pfet_05v0 ad=0.2028p pd=1.3u as=0.2028p ps=1.3u w=0.78u l=0.5u
X261 VSS a_5208_4472# a_2936_3438# VSS nfet_05v0 ad=0.2486p pd=2.01u as=0.1469p ps=1.085u w=0.565u l=0.6u
X262 VSS a_4233_9040# a_4128_9180# VSS nfet_05v0 ad=0.1224p pd=1.04u as=94.5f ps=0.885u w=0.36u l=0.6u
X263 VDD a_7292_1943# a_7204_2040# VDD pfet_05v0 ad=0.5368p pd=3.32u as=0.5368p ps=3.32u w=1.22u l=1u
X264 a_1246_9880# a_1324_4765# VSS VSS nfet_05v0 ad=0.1469p pd=1.085u as=0.2486p ps=2.01u w=0.565u l=0.6u
X265 a_2772_8780# a_2176_4292# VDD VDD pfet_05v0 ad=0.3432p pd=2.44u as=0.45p ps=2.02u w=0.78u l=0.5u
X266 a_5208_4472# a_4828_3944# a_5208_3988# VDD pfet_05v0 ad=0.3172p pd=1.74u as=0.3172p ps=1.74u w=1.22u l=0.5u
X267 VDD a_7721_6040# a_7759_7125# VDD pfet_05v0 ad=0.2197p pd=1.365u as=0.2197p ps=1.365u w=0.845u l=0.5u
X268 a_8489_4336# a_8072_4476# a_8865_4476# VSS nfet_05v0 ad=0.176p pd=1.68u as=0.134p ps=1.1u w=0.4u l=0.6u
X269 a_6620_4076# a_6520_4032# VDD VDD pfet_05v0 ad=0.2028p pd=1.3u as=0.3432p ps=2.44u w=0.78u l=0.5u
X270 a_6396_10216# a_6308_10260# VSS VSS nfet_05v0 ad=0.3608p pd=2.52u as=0.3608p ps=2.52u w=0.82u l=1u
X271 a_7020_8736# a_6712_8780# VSS VSS nfet_05v0 ad=0.2007p pd=1.475u as=0.2016p ps=1.48u w=0.36u l=0.6u
X272 a_6160_8763# a_5748_9176# VDD VDD pfet_05v0 ad=0.3806p pd=2.61u as=0.2249p ps=1.385u w=0.865u l=0.5u
X273 a_8412_10216# a_8324_10260# VSS VSS nfet_05v0 ad=0.3608p pd=2.52u as=0.3608p ps=2.52u w=0.82u l=1u
X274 a_2920_1724# a_1120_2040# a_1980_1991# VSS nfet_05v0 ad=0.2007p pd=1.475u as=0.2007p ps=1.475u w=0.36u l=0.6u
X275 a_6824_4076# a_5860_4472# a_6620_4076# VSS nfet_05v0 ad=93.59999f pd=0.88u as=93.59999f ps=0.88u w=0.36u l=0.6u
X276 a_1704_2464# a_3337_1680# VDD VDD pfet_05v0 ad=0.5346p pd=3.31u as=0.5346p ps=3.31u w=1.215u l=0.5u
X277 VDD a_8076_9783# a_7988_9880# VDD pfet_05v0 ad=0.5368p pd=3.32u as=0.5368p ps=3.32u w=1.22u l=1u
X278 VSS a_1020_7552# a_5748_9176# VSS nfet_05v0 ad=0.1053p pd=0.925u as=0.1782p ps=1.69u w=0.405u l=0.6u
X279 a_1804_2508# a_1704_2464# VSS VSS nfet_05v0 ad=93.59999f pd=0.88u as=0.1584p ps=1.6u w=0.36u l=0.6u
X280 a_1244_10216# a_1156_10260# VSS VSS nfet_05v0 ad=0.3608p pd=2.52u as=0.3608p ps=2.52u w=0.82u l=1u
X281 a_3337_1680# rst_n VDD VDD pfet_05v0 ad=0.26p pd=1.52u as=0.29465p ps=1.74u w=1u l=0.5u
X282 VSS a_2408_6296# a_1548_9469# VSS nfet_05v0 ad=0.218p pd=1.52u as=0.2132p ps=1.34u w=0.82u l=0.6u
X283 a_2112_5176# clk_feedback VDD VDD pfet_05v0 ad=0.44955p pd=1.955u as=0.5346p ps=3.31u w=1.215u l=0.5u
X284 a_8860_10216# a_8772_10260# VSS VSS nfet_05v0 ad=0.3608p pd=2.52u as=0.3608p ps=2.52u w=0.82u l=1u
X285 a_2876_8736# a_2568_8780# VDD VDD pfet_05v0 ad=0.2424p pd=1.465u as=0.2222p ps=1.89u w=0.505u l=0.5u
X286 clk_feedback a_3337_4336# VDD VDD pfet_05v0 ad=0.5346p pd=3.31u as=0.5346p ps=3.31u w=1.215u l=0.5u
X287 VDD a_2316_8263# a_2212_8312# VDD pfet_05v0 ad=0.45p pd=2.02u as=0.2028p ps=1.3u w=0.78u l=0.5u
X288 a_3232_1724# a_1120_2040# a_2920_1724# VDD pfet_05v0 ad=0.1313p pd=1.025u as=0.25375p ps=1.51u w=0.505u l=0.5u
X289 a_5281_3292# a_2176_4292# VSS VSS nfet_05v0 ad=0.134p pd=1.1u as=0.1224p ps=1.04u w=0.36u l=0.6u
X290 a_2264_8736# a_1806_10260# a_2472_10260# VDD pfet_05v0 ad=0.3172p pd=1.74u as=0.5368p ps=3.32u w=1.22u l=0.5u
X291 a_1456_2491# a_1044_2904# VDD VDD pfet_05v0 ad=0.3806p pd=2.61u as=0.2249p ps=1.385u w=0.865u l=0.5u
X292 a_5508_7564# a_5457_9456# VSS VSS nfet_05v0 ad=93.59999f pd=0.88u as=0.218p ps=1.52u w=0.36u l=0.6u
X293 clk_feedback a_3337_4336# VSS VSS nfet_05v0 ad=0.3586p pd=2.51u as=0.3586p ps=2.51u w=0.815u l=0.6u
X294 a_5724_5079# a_5636_5176# VSS VSS nfet_05v0 ad=0.3608p pd=2.52u as=0.3608p ps=2.52u w=0.82u l=1u
X295 VDD a_4828_3944# a_7329_5557# VDD pfet_05v0 ad=0.3159p pd=1.735u as=0.5346p ps=3.31u w=1.215u l=0.5u
X296 a_2120_6340# a_2000_6296# VSS VSS nfet_05v0 ad=0.1312p pd=1.14u as=0.3608p ps=2.52u w=0.82u l=0.6u
X297 VDD a_4828_3944# a_4724_3988# VDD pfet_05v0 ad=0.4005p pd=2.12u as=0.1456p ps=1.08u w=0.56u l=0.5u
X298 a_9084_8215# a_8996_8312# VSS VSS nfet_05v0 ad=0.3608p pd=2.52u as=0.3608p ps=2.52u w=0.82u l=1u
X299 a_7000_8312# a_6328_8444# VDD VDD pfet_05v0 ad=0.3172p pd=1.74u as=0.4005p ps=2.12u w=1.22u l=0.5u
X300 VDD a_796_1675# a_2276_3287# VDD pfet_05v0 ad=0.2249p pd=1.385u as=0.3806p ps=2.61u w=0.865u l=0.5u
X301 VSS a_2176_4292# a_2128_4476# VSS nfet_05v0 ad=0.2016p pd=1.48u as=43.2f ps=0.6u w=0.36u l=0.6u
X302 a_2112_5176# a_2444_4728# a_1548_4765# VDD pfet_05v0 ad=0.5346p pd=3.31u as=0.3159p ps=1.735u w=1.215u l=0.5u
X303 a_7847_6744# a_5500_6324# VDD VDD pfet_05v0 ad=0.37665p pd=1.835u as=0.5346p ps=3.31u w=1.215u l=0.5u
X304 VSS a_3696_5556# a_3584_9743# VSS nfet_05v0 ad=0.1183p pd=0.975u as=0.1183p ps=0.975u w=0.455u l=0.6u
X305 a_1244_8648# a_1156_8692# VSS VSS nfet_05v0 ad=0.3608p pd=2.52u as=0.3608p ps=2.52u w=0.82u l=1u
X306 a_1120_4059# a_708_4472# VSS VSS nfet_05v0 ad=0.1782p pd=1.69u as=0.1053p ps=0.925u w=0.405u l=0.6u
X307 a_7336_9880# a_2744_10700# a_7336_9476# VDD pfet_05v0 ad=0.5368p pd=3.32u as=0.3172p ps=1.74u w=1.22u l=0.5u
X308 VSS a_796_1675# a_2276_3287# VSS nfet_05v0 ad=0.1053p pd=0.925u as=0.1782p ps=1.69u w=0.405u l=0.6u
X309 VSS cfg_divider[1] a_6328_8444# VSS nfet_05v0 ad=0.218p pd=1.52u as=93.59999f ps=0.88u w=0.36u l=0.6u
X310 VSS a_3584_9743# a_2632_9502# VSS nfet_05v0 ad=0.2662p pd=2.09u as=0.2662p ps=2.09u w=0.605u l=0.6u
X311 a_2744_10700# a_4233_9040# VSS VSS nfet_05v0 ad=0.3586p pd=2.51u as=0.3586p ps=2.51u w=0.815u l=0.6u
X312 a_2856_4798# a_3584_9743# VDD VDD pfet_05v0 ad=0.2542p pd=1.44u as=0.428p ps=2.02u w=0.82u l=0.5u
X313 a_2856_5556# cfg_divider[5] a_2856_6040# VDD pfet_05v0 ad=0.5368p pd=3.32u as=0.3172p ps=1.74u w=1.22u l=0.5u
X314 VDD a_4828_5079# a_4740_5176# VDD pfet_05v0 ad=0.5368p pd=3.32u as=0.5368p ps=3.32u w=1.22u l=1u
X315 a_6408_8736# a_4604_4495# a_6516_6340# VSS nfet_05v0 ad=0.2569p pd=1.56u as=0.1312p ps=1.14u w=0.82u l=0.6u
X316 a_8377_9040# a_2176_4292# VDD VDD pfet_05v0 ad=0.26p pd=1.52u as=0.29465p ps=1.74u w=1u l=0.5u
X317 a_8384_4476# a_5860_4472# a_8072_4476# VSS nfet_05v0 ad=94.5f pd=0.885u as=0.2007p ps=1.475u w=0.36u l=0.6u
X318 VDD a_7132_4032# a_7028_4076# VDD pfet_05v0 ad=0.45p pd=2.02u as=0.2028p ps=1.3u w=0.78u l=0.5u
X319 a_7944_7908# a_5457_9456# VSS VSS nfet_05v0 ad=0.1312p pd=1.14u as=0.3608p ps=2.52u w=0.82u l=0.6u
X320 a_1468_4076# a_1246_5176# VSS VSS nfet_05v0 ad=93.59999f pd=0.88u as=0.1584p ps=1.6u w=0.36u l=0.6u
X321 a_4604_9783# a_4516_9880# VSS VSS nfet_05v0 ad=0.3608p pd=2.52u as=0.3608p ps=2.52u w=0.82u l=1u
X322 a_5368_8337# a_2000_6296# a_5164_8337# VDD pfet_05v0 ad=0.58035p pd=2.155u as=0.2847p ps=1.615u w=1.095u l=0.5u
X323 VDD a_4905_3248# a_4800_3292# VDD pfet_05v0 ad=0.29465p pd=1.74u as=0.1313p ps=1.025u w=0.505u l=0.5u
X324 VSS a_4828_3944# a_5724_6324# VSS nfet_05v0 ad=0.2112p pd=1.84u as=0.2112p ps=1.84u w=0.48u l=0.6u
X325 a_8691_6875# a_7825_5512# VSS VSS nfet_05v0 ad=93.59999f pd=0.88u as=0.1584p ps=1.6u w=0.36u l=0.6u
X326 VDD a_3673_7952# a_3568_7996# VDD pfet_05v0 ad=0.29465p pd=1.74u as=0.1313p ps=1.025u w=0.505u l=0.5u
X327 a_5500_6324# a_8377_2768# VDD VDD pfet_05v0 ad=0.5346p pd=3.31u as=0.5346p ps=3.31u w=1.215u l=0.5u
X328 VSS rst_n a_2128_1724# VSS nfet_05v0 ad=0.2016p pd=1.48u as=43.2f ps=0.6u w=0.36u l=0.6u
X329 VDD a_9084_1943# a_8996_2040# VDD pfet_05v0 ad=0.5368p pd=3.32u as=0.5368p ps=3.32u w=1.22u l=1u
X330 a_2876_8736# a_2568_8780# VSS VSS nfet_05v0 ad=0.2007p pd=1.475u as=0.2016p ps=1.48u w=0.36u l=0.6u
X331 VSS a_4828_3944# a_4536_3988# VSS nfet_05v0 ad=0.218p pd=1.52u as=93.59999f ps=0.88u w=0.36u l=0.6u
X332 VSS a_4604_4495# a_5432_4472# VSS nfet_05v0 ad=0.3608p pd=2.52u as=0.1312p ps=1.14u w=0.82u l=0.6u
X333 a_3816_9180# a_1604_9176# a_2876_8736# VDD pfet_05v0 ad=0.25375p pd=1.51u as=0.2424p ps=1.465u w=0.505u l=0.5u
X334 a_2316_8263# a_2008_8312# VSS VSS nfet_05v0 ad=0.2007p pd=1.475u as=0.2016p ps=1.48u w=0.36u l=0.6u
X335 VSS a_2176_4292# a_7280_4476# VSS nfet_05v0 ad=0.2016p pd=1.48u as=43.2f ps=0.6u w=0.36u l=0.6u
X336 VDD a_6844_7080# a_6756_7124# VDD pfet_05v0 ad=0.5368p pd=3.32u as=0.5368p ps=3.32u w=1.22u l=1u
X337 a_4128_9180# a_1604_9176# a_3816_9180# VSS nfet_05v0 ad=94.5f pd=0.885u as=0.2007p ps=1.475u w=0.36u l=0.6u
X338 VSS a_3696_5556# a_3584_9743# VSS nfet_05v0 ad=0.2002p pd=1.79u as=0.1183p ps=0.975u w=0.455u l=0.6u
X339 VSS a_1020_7552# a_1604_9176# VSS nfet_05v0 ad=0.1053p pd=0.925u as=0.1782p ps=1.69u w=0.405u l=0.6u
X340 a_2936_3438# a_1324_4765# VSS VSS nfet_05v0 ad=0.1469p pd=1.085u as=0.2486p ps=2.01u w=0.565u l=0.6u
X341 a_4049_2908# rst_n VSS VSS nfet_05v0 ad=0.134p pd=1.1u as=0.1224p ps=1.04u w=0.36u l=0.6u
X342 VDD cfg_divider[5] a_1364_6296# VDD pfet_05v0 ad=0.5368p pd=3.32u as=0.5368p ps=3.32u w=1.22u l=0.5u
X343 a_7412_10758# a_7336_9476# a_7392_10260# VDD pfet_05v0 ad=0.5368p pd=3.32u as=0.4087p ps=1.89u w=1.22u l=0.5u
X344 a_1896_7212# a_1344_7195# a_1692_7212# VDD pfet_05v0 ad=0.2028p pd=1.3u as=0.2028p ps=1.3u w=0.78u l=0.5u
X345 VDD a_3144_7612# a_3561_7472# VDD pfet_05v0 ad=0.44p pd=2.88u as=0.26p ps=1.52u w=1u l=0.5u
X346 a_6844_1943# a_6756_2040# VSS VSS nfet_05v0 ad=0.3608p pd=2.52u as=0.3608p ps=2.52u w=0.82u l=1u
X347 a_7329_5557# a_1096_6296# a_7721_6040# VDD pfet_05v0 ad=0.5346p pd=3.31u as=0.3159p ps=1.735u w=1.215u l=0.5u
X348 a_3024_9180# a_2876_8736# a_2856_9180# VSS nfet_05v0 ad=43.2f pd=0.6u as=43.2f ps=0.6u w=0.36u l=0.6u
X349 VSS a_8377_2768# a_8272_2908# VSS nfet_05v0 ad=0.1224p pd=1.04u as=94.5f ps=0.885u w=0.36u l=0.6u
X350 a_1468_2040# a_1345_3608# VSS VSS nfet_05v0 ad=93.59999f pd=0.88u as=0.1584p ps=1.6u w=0.36u l=0.6u
X351 a_3820_10216# a_3732_10260# VSS VSS nfet_05v0 ad=0.3608p pd=2.52u as=0.3608p ps=2.52u w=0.82u l=1u
X352 a_7560_9476# cfg_divider[2] a_7336_9476# VSS nfet_05v0 ad=0.1312p pd=1.14u as=0.2132p ps=1.34u w=0.82u l=0.6u
X353 VDD a_7960_2908# a_8377_2768# VDD pfet_05v0 ad=0.44p pd=2.88u as=0.26p ps=1.52u w=1u l=0.5u
X354 VSS a_1096_6296# a_7945_6040# VSS nfet_05v0 ad=0.3586p pd=2.51u as=0.1304p ps=1.135u w=0.815u l=0.6u
X355 a_6620_4076# a_6520_4032# VSS VSS nfet_05v0 ad=93.59999f pd=0.88u as=0.1584p ps=1.6u w=0.36u l=0.6u
X356 a_2372_5556# cfg_divider[5] a_2184_5556# VDD pfet_05v0 ad=0.1456p pd=1.08u as=0.2464p ps=2u w=0.56u l=0.5u
X357 VDD a_9308_10216# a_9220_10260# VDD pfet_05v0 ad=0.5368p pd=3.32u as=0.5368p ps=3.32u w=1.22u l=1u
X358 a_2100_7212# a_2176_4292# VDD VDD pfet_05v0 ad=0.3432p pd=2.44u as=0.45p ps=2.02u w=0.78u l=0.5u
X359 VDD a_5164_10216# a_5076_10260# VDD pfet_05v0 ad=0.5368p pd=3.32u as=0.5368p ps=3.32u w=1.22u l=1u
X360 a_8251_7552# a_8691_6875# VSS VSS nfet_05v0 ad=0.3608p pd=2.52u as=0.2288p ps=1.58u w=0.82u l=0.6u
X361 a_4233_9040# a_2176_4292# VDD VDD pfet_05v0 ad=0.26p pd=1.52u as=0.29465p ps=1.74u w=1u l=0.5u
X362 a_8748_5079# a_8660_5176# VSS VSS nfet_05v0 ad=0.3608p pd=2.52u as=0.3608p ps=2.52u w=0.82u l=1u
X363 a_5500_1943# a_5412_2040# VSS VSS nfet_05v0 ad=0.3608p pd=2.52u as=0.3608p ps=2.52u w=0.82u l=1u
X364 a_6888_3160# a_6404_6054# a_7268_3740# VDD pfet_05v0 ad=0.2464p pd=2u as=0.1456p ps=1.08u w=0.56u l=0.5u
X365 VDD a_5185_9432# a_5052_6324# VDD pfet_05v0 ad=0.38705p pd=2.08u as=0.5368p ps=3.32u w=1.22u l=0.5u
X366 a_6508_8780# a_6408_8736# VDD VDD pfet_05v0 ad=0.2028p pd=1.3u as=0.3432p ps=2.44u w=0.78u l=0.5u
X367 a_3673_2768# a_3256_2908# a_4049_2908# VSS nfet_05v0 ad=0.176p pd=1.68u as=0.134p ps=1.1u w=0.4u l=0.6u
X368 a_3444_3608# a_2276_3287# a_3240_3608# VDD pfet_05v0 ad=0.2028p pd=1.3u as=0.2028p ps=1.3u w=0.78u l=0.5u
X369 a_3713_4476# a_2176_4292# VSS VSS nfet_05v0 ad=0.134p pd=1.1u as=0.1224p ps=1.04u w=0.36u l=0.6u
X370 VDD a_8232_7864# a_7736_8312# VDD pfet_05v0 ad=0.4005p pd=2.12u as=0.3172p ps=1.74u w=1.22u l=0.5u
X371 a_2204_7168# a_1896_7212# VDD VDD pfet_05v0 ad=0.2424p pd=1.465u as=0.2222p ps=1.89u w=0.505u l=0.5u
X372 a_6508_2508# a_6408_2464# VDD VDD pfet_05v0 ad=0.2028p pd=1.3u as=0.3432p ps=2.44u w=0.78u l=0.5u
X373 a_6328_8444# a_2000_6296# VSS VSS nfet_05v0 ad=93.59999f pd=0.88u as=0.1584p ps=1.6u w=0.36u l=0.6u
X374 VDD a_3256_7996# a_3673_7952# VDD pfet_05v0 ad=0.44p pd=2.88u as=0.26p ps=1.52u w=1u l=0.5u
X375 VSS a_8377_9040# a_8272_9180# VSS nfet_05v0 ad=0.1224p pd=1.04u as=94.5f ps=0.885u w=0.36u l=0.6u
X376 a_7112_4476# a_6272_4059# a_6824_4076# VSS nfet_05v0 ad=43.2f pd=0.6u as=93.59999f ps=0.88u w=0.36u l=0.6u
X377 a_2204_7168# a_1896_7212# VSS VSS nfet_05v0 ad=0.2007p pd=1.475u as=0.2016p ps=1.48u w=0.36u l=0.6u
X378 a_7600_5176# a_1324_4765# VDD VDD pfet_05v0 ad=0.44955p pd=1.955u as=0.5346p ps=3.31u w=1.215u l=0.5u
X379 a_2008_2508# a_1044_2904# a_1804_2508# VSS nfet_05v0 ad=93.59999f pd=0.88u as=93.59999f ps=0.88u w=0.36u l=0.6u
X380 a_1245_3160# a_1245_3160# VSS VSS nfet_05v0 ad=0.3608p pd=2.52u as=0.3608p ps=2.52u w=0.82u l=0.6u
X381 a_5508_7564# a_2000_6296# VSS VSS nfet_05v0 ad=0.126p pd=1.06u as=93.59999f ps=0.88u w=0.36u l=0.6u
X382 VDD a_2408_6296# a_1912_6744# VDD pfet_05v0 ad=0.4005p pd=2.12u as=0.3172p ps=1.74u w=1.22u l=0.5u
X383 a_3548_3559# a_3240_3608# VDD VDD pfet_05v0 ad=0.2424p pd=1.465u as=0.2222p ps=1.89u w=0.505u l=0.5u
X384 a_3584_9743# a_3696_5556# VDD VDD pfet_05v0 ad=0.3782p pd=1.84u as=0.3782p ps=1.84u w=1.22u l=0.5u
X385 a_2316_8263# a_2008_8312# VDD VDD pfet_05v0 ad=0.2424p pd=1.465u as=0.2222p ps=1.89u w=0.505u l=0.5u
X386 VSS a_796_1675# a_708_4472# VSS nfet_05v0 ad=0.1053p pd=0.925u as=0.1782p ps=1.69u w=0.405u l=0.6u
X387 a_6888_3160# a_5500_6324# VSS VSS nfet_05v0 ad=93.59999f pd=0.88u as=0.218p ps=1.52u w=0.36u l=0.6u
X388 a_7600_5176# a_7759_7125# a_6520_4032# VDD pfet_05v0 ad=0.5346p pd=3.31u as=0.3159p ps=1.735u w=1.215u l=0.5u
X389 a_2856_9180# a_2016_8763# a_2568_8780# VSS nfet_05v0 ad=43.2f pd=0.6u as=93.59999f ps=0.88u w=0.36u l=0.6u
X390 a_8177_7608# a_7639_6362# a_7973_7608# VSS nfet_05v0 ad=0.1517p pd=1.19u as=0.1722p ps=1.24u w=0.82u l=0.6u
X391 a_3713_1724# rst_n VSS VSS nfet_05v0 ad=0.134p pd=1.1u as=0.1224p ps=1.04u w=0.36u l=0.6u
X392 VSS a_2744_10700# a_5508_7564# VSS nfet_05v0 ad=93.59999f pd=0.88u as=93.59999f ps=0.88u w=0.36u l=0.6u
X393 a_1548_9469# a_2000_6296# a_1912_6744# VDD pfet_05v0 ad=0.3172p pd=1.74u as=0.5368p ps=3.32u w=1.22u l=0.5u
X394 a_4536_3988# a_4604_4495# VSS VSS nfet_05v0 ad=93.59999f pd=0.88u as=0.1584p ps=1.6u w=0.36u l=0.6u
X395 VSS a_3584_9743# a_2856_4798# VSS nfet_05v0 ad=0.2662p pd=2.09u as=0.2662p ps=2.09u w=0.605u l=0.6u
X396 VSS a_5457_9456# a_5164_7909# VSS nfet_05v0 ad=0.3586p pd=2.51u as=0.2119p ps=1.335u w=0.815u l=0.6u
X397 a_8072_4476# a_5860_4472# a_7132_4032# VDD pfet_05v0 ad=0.25375p pd=1.51u as=0.2424p ps=1.465u w=0.505u l=0.5u
X398 a_8865_4476# a_2176_4292# VSS VSS nfet_05v0 ad=0.134p pd=1.1u as=0.1224p ps=1.04u w=0.36u l=0.6u
X399 a_1344_7195# a_932_7608# VDD VDD pfet_05v0 ad=0.3806p pd=2.61u as=0.2249p ps=1.385u w=0.865u l=0.5u
X400 a_8636_1943# a_8548_2040# VSS VSS nfet_05v0 ad=0.3608p pd=2.52u as=0.3608p ps=2.52u w=0.82u l=1u
X401 a_8071_6744# a_7924_8312# a_7847_6744# VDD pfet_05v0 ad=0.37665p pd=1.835u as=0.37665p ps=1.835u w=1.215u l=0.5u
X402 a_3708_6647# a_3620_6744# VSS VSS nfet_05v0 ad=0.3608p pd=2.52u as=0.3608p ps=2.52u w=0.82u l=1u
X403 a_7020_8736# a_6712_8780# VDD VDD pfet_05v0 ad=0.2424p pd=1.465u as=0.2222p ps=1.89u w=0.505u l=0.5u
X404 a_1216_6744# a_1096_6296# VDD VDD pfet_05v0 ad=0.44955p pd=1.955u as=0.5346p ps=3.31u w=1.215u l=0.5u
X405 VSS a_2744_10700# a_7560_9476# VSS nfet_05v0 ad=0.3608p pd=2.52u as=0.1312p ps=1.14u w=0.82u l=0.6u
X406 a_5888_7124# a_5457_9456# VDD VDD pfet_05v0 ad=0.1736p pd=1.18u as=0.389p ps=2.02u w=0.56u l=0.5u
X407 a_7020_2464# a_6712_2508# VDD VDD pfet_05v0 ad=0.2424p pd=1.465u as=0.2222p ps=1.89u w=0.505u l=0.5u
X408 a_8384_4476# a_6272_4059# a_8072_4476# VDD pfet_05v0 ad=0.1313p pd=1.025u as=0.25375p ps=1.51u w=0.505u l=0.5u
X409 a_5577_10011# a_5457_9456# VDD VDD pfet_05v0 ad=0.1469p pd=1.085u as=0.38705p ps=2.08u w=0.565u l=0.5u
X410 VDD a_1548_9469# a_1434_9880# VDD pfet_05v0 ad=0.5368p pd=3.32u as=0.4087p ps=1.89u w=1.22u l=0.5u
X411 a_1324_4765# a_4604_4495# VSS VSS nfet_05v0 ad=0.1209p pd=0.985u as=0.2046p ps=1.81u w=0.465u l=0.6u
X412 a_1216_6744# a_1324_4765# a_1216_6340# VDD pfet_05v0 ad=0.5346p pd=3.31u as=0.3159p ps=1.735u w=1.215u l=0.5u
X413 VDD a_4716_10216# a_4628_10260# VDD pfet_05v0 ad=0.5368p pd=3.32u as=0.5368p ps=3.32u w=1.22u l=1u
X414 a_2364_8780# a_2264_8736# VDD VDD pfet_05v0 ad=0.2028p pd=1.3u as=0.3432p ps=2.44u w=0.78u l=0.5u
X415 VSS a_1096_6296# a_8691_6875# VSS nfet_05v0 ad=0.2288p pd=1.58u as=93.59999f ps=0.88u w=0.36u l=0.6u
X416 a_2176_4292# a_3673_2768# VSS VSS nfet_05v0 ad=0.3586p pd=2.51u as=0.3586p ps=2.51u w=0.815u l=0.6u
X417 a_4488_3292# a_2276_3287# a_3548_3559# VDD pfet_05v0 ad=0.25375p pd=1.51u as=0.2424p ps=1.465u w=0.505u l=0.5u
X418 a_2856_6040# a_1096_6296# a_2856_5556# VDD pfet_05v0 ad=0.3172p pd=1.74u as=0.3172p ps=1.74u w=1.22u l=0.5u
X419 a_2016_8763# a_1604_9176# VDD VDD pfet_05v0 ad=0.3806p pd=2.61u as=0.2249p ps=1.385u w=0.865u l=0.5u
X420 a_7868_4772# a_7748_4728# a_6520_4032# VSS nfet_05v0 ad=0.1312p pd=1.14u as=0.2569p ps=1.56u w=0.82u l=0.6u
X421 a_7759_7125# a_8251_7552# a_8177_7608# VSS nfet_05v0 ad=0.3608p pd=2.52u as=0.1517p ps=1.19u w=0.82u l=0.6u
X422 a_6852_10012# a_2744_10700# a_6664_10012# VDD pfet_05v0 ad=0.1456p pd=1.08u as=0.2464p ps=2u w=0.56u l=0.5u
X423 VDD a_5724_5079# a_5636_5176# VDD pfet_05v0 ad=0.5368p pd=3.32u as=0.5368p ps=3.32u w=1.22u l=1u
X424 VSS cfg_divider[0] a_7825_5512# VSS nfet_05v0 ad=0.2112p pd=1.84u as=0.2112p ps=1.84u w=0.48u l=0.6u
X425 VSS a_3673_7952# a_3568_7996# VSS nfet_05v0 ad=0.1224p pd=1.04u as=94.5f ps=0.885u w=0.36u l=0.6u
X426 a_1456_2491# a_1044_2904# VSS VSS nfet_05v0 ad=0.1782p pd=1.69u as=0.1053p ps=0.925u w=0.405u l=0.6u
X427 a_5276_5079# a_5188_5176# VSS VSS nfet_05v0 ad=0.3608p pd=2.52u as=0.3608p ps=2.52u w=0.82u l=1u
X428 VSS rst_n a_2464_2908# VSS nfet_05v0 ad=0.2016p pd=1.48u as=43.2f ps=0.6u w=0.36u l=0.6u
X429 a_4800_3292# a_2688_3608# a_4488_3292# VDD pfet_05v0 ad=0.1313p pd=1.025u as=0.25375p ps=1.51u w=0.505u l=0.5u
X430 a_5208_3988# a_4536_3988# VDD VDD pfet_05v0 ad=0.3172p pd=1.74u as=0.4005p ps=2.12u w=1.22u l=0.5u
X431 a_7759_7125# a_7412_10758# VDD VDD pfet_05v0 ad=0.2197p pd=1.365u as=0.3718p ps=2.57u w=0.845u l=0.5u
X432 a_4828_7080# a_4740_7124# VSS VSS nfet_05v0 ad=0.3608p pd=2.52u as=0.3608p ps=2.52u w=0.82u l=1u
X433 a_1324_4765# a_4828_3944# a_6832_5176# VDD pfet_05v0 ad=0.5368p pd=3.32u as=0.3782p ps=1.84u w=1.22u l=0.5u
X434 a_796_5079# a_708_5176# VSS VSS nfet_05v0 ad=0.3608p pd=2.52u as=0.3608p ps=2.52u w=0.82u l=1u
X435 a_7960_9180# a_5748_9176# a_7020_8736# VDD pfet_05v0 ad=0.25375p pd=1.51u as=0.2424p ps=1.465u w=0.505u l=0.5u
X436 a_796_1675# a_2856_4798# VDD VDD pfet_05v0 ad=0.3782p pd=1.84u as=0.5368p ps=3.32u w=1.22u l=0.5u
X437 VSS a_796_1675# a_5748_2904# VSS nfet_05v0 ad=0.1053p pd=0.925u as=0.1782p ps=1.69u w=0.405u l=0.6u
X438 a_7960_2908# a_5748_2904# a_7020_2464# VDD pfet_05v0 ad=0.25375p pd=1.51u as=0.2424p ps=1.465u w=0.505u l=0.5u
X439 a_8072_4476# a_6272_4059# a_7132_4032# VSS nfet_05v0 ad=0.2007p pd=1.475u as=0.2007p ps=1.475u w=0.36u l=0.6u
X440 a_1324_4765# a_4828_3944# VSS VSS nfet_05v0 ad=0.2046p pd=1.81u as=0.1209p ps=0.985u w=0.465u l=0.6u
X441 a_4268_10216# a_4180_10260# VSS VSS nfet_05v0 ad=0.3608p pd=2.52u as=0.3608p ps=2.52u w=0.82u l=1u
X442 a_796_1675# a_2856_4798# VSS VSS nfet_05v0 ad=0.1183p pd=0.975u as=0.2002p ps=1.79u w=0.455u l=0.6u
X443 a_3561_7472# a_2176_4292# VDD VDD pfet_05v0 ad=0.26p pd=1.52u as=0.29465p ps=1.74u w=1u l=0.5u
X444 a_1434_5176# a_1324_4765# a_1246_5176# VDD pfet_05v0 ad=0.4087p pd=1.89u as=0.5368p ps=3.32u w=1.22u l=0.5u
X445 VDD a_2968_10216# a_2472_10260# VDD pfet_05v0 ad=0.4005p pd=2.12u as=0.3172p ps=1.74u w=1.22u l=0.5u
X446 a_7721_6040# a_7825_5512# a_7329_5557# VDD pfet_05v0 ad=0.3159p pd=1.735u as=0.3159p ps=1.735u w=1.215u l=0.5u
X447 VDD a_3696_5556# a_3584_9743# VDD pfet_05v0 ad=0.3782p pd=1.84u as=0.3782p ps=1.84u w=1.22u l=0.5u
X448 a_7740_1943# a_7652_2040# VSS VSS nfet_05v0 ad=0.3608p pd=2.52u as=0.3608p ps=2.52u w=0.82u l=1u
X449 a_4156_9783# a_4068_9880# VSS VSS nfet_05v0 ad=0.3608p pd=2.52u as=0.3608p ps=2.52u w=0.82u l=1u
X450 a_796_8648# a_708_8692# VSS VSS nfet_05v0 ad=0.3608p pd=2.52u as=0.3608p ps=2.52u w=0.82u l=1u
X451 VDD a_2856_4798# a_796_1675# VDD pfet_05v0 ad=0.428p pd=2.02u as=0.3782p ps=1.84u w=1.22u l=0.5u
X452 a_1456_8312# a_1044_7991# VSS VSS nfet_05v0 ad=0.1782p pd=1.69u as=0.1053p ps=0.925u w=0.405u l=0.6u
X453 a_6404_6054# a_4828_3944# a_6384_5556# VDD pfet_05v0 ad=0.5368p pd=3.32u as=0.4087p ps=1.89u w=1.22u l=0.5u
X454 VSS a_6888_3160# a_6408_2464# VSS nfet_05v0 ad=0.218p pd=1.52u as=0.2132p ps=1.34u w=0.82u l=0.6u
X455 a_8251_7552# a_8691_6875# VDD VDD pfet_05v0 ad=0.5368p pd=3.32u as=0.38705p ps=2.08u w=1.22u l=0.5u
X456 VSS a_2856_4798# a_796_1675# VSS nfet_05v0 ad=0.2002p pd=1.79u as=0.1183p ps=0.975u w=0.455u l=0.6u
X457 a_2568_8780# a_1604_9176# a_2364_8780# VSS nfet_05v0 ad=93.59999f pd=0.88u as=93.59999f ps=0.88u w=0.36u l=0.6u
X458 VSS cfg_divider[2] a_6664_10012# VSS nfet_05v0 ad=0.218p pd=1.52u as=93.59999f ps=0.88u w=0.36u l=0.6u
X459 a_1120_4059# a_708_4472# VDD VDD pfet_05v0 ad=0.3806p pd=2.61u as=0.2249p ps=1.385u w=0.865u l=0.5u
X460 a_7779_7608# a_7412_10758# VSS VSS nfet_05v0 ad=0.1517p pd=1.19u as=0.3608p ps=2.52u w=0.82u l=0.6u
X461 a_6600_3204# a_6404_6054# VSS VSS nfet_05v0 ad=0.1312p pd=1.14u as=0.3608p ps=2.52u w=0.82u l=0.6u
X462 a_2000_6296# a_3673_7952# VDD VDD pfet_05v0 ad=0.5346p pd=3.31u as=0.5346p ps=3.31u w=1.215u l=0.5u
X463 a_5172_6744# a_5052_6324# VDD VDD pfet_05v0 ad=0.3172p pd=1.74u as=0.5368p ps=3.32u w=1.22u l=0.5u
X464 a_6396_1943# a_6308_2040# VSS VSS nfet_05v0 ad=0.3608p pd=2.52u as=0.3608p ps=2.52u w=0.82u l=1u
X465 VDD a_3561_7472# a_3456_7612# VDD pfet_05v0 ad=0.29465p pd=1.74u as=0.1313p ps=1.025u w=0.505u l=0.5u
X466 VDD a_2920_4476# a_3337_4336# VDD pfet_05v0 ad=0.44p pd=2.88u as=0.26p ps=1.52u w=1u l=0.5u
X467 VSS a_3561_7472# a_3456_7612# VSS nfet_05v0 ad=0.1224p pd=1.04u as=94.5f ps=0.885u w=0.36u l=0.6u
X468 a_1345_3608# a_1245_3160# VDD VDD pfet_05v0 ad=0.5368p pd=3.32u as=0.5368p ps=3.32u w=1.22u l=0.5u
X469 a_7412_10758# a_7000_7908# VSS VSS nfet_05v0 ad=0.1469p pd=1.085u as=0.2486p ps=2.01u w=0.565u l=0.6u
X470 a_8377_2768# a_7960_2908# a_8753_2908# VSS nfet_05v0 ad=0.176p pd=1.68u as=0.134p ps=1.1u w=0.4u l=0.6u
X471 a_2464_2908# a_2316_2464# a_2296_2908# VSS nfet_05v0 ad=43.2f pd=0.6u as=43.2f ps=0.6u w=0.36u l=0.6u
X472 VDD a_4488_3292# a_4905_3248# VDD pfet_05v0 ad=0.44p pd=2.88u as=0.26p ps=1.52u w=1u l=0.5u
X473 modulus_33 a_8489_4336# VDD VDD pfet_05v0 ad=0.5346p pd=3.31u as=0.5346p ps=3.31u w=1.215u l=0.5u
X474 VDD a_3696_5556# a_3584_9743# VDD pfet_05v0 ad=0.5368p pd=3.32u as=0.3782p ps=1.84u w=1.22u l=0.5u
X475 a_4380_5079# a_4292_5176# VSS VSS nfet_05v0 ad=0.3608p pd=2.52u as=0.3608p ps=2.52u w=0.82u l=1u
X476 modulus_33 a_8489_4336# VSS VSS nfet_05v0 ad=0.3586p pd=2.51u as=0.3586p ps=2.51u w=0.815u l=0.6u
X477 VSS a_6404_6054# a_6888_3160# VSS nfet_05v0 ad=0.1584p pd=1.6u as=93.59999f ps=0.88u w=0.36u l=0.6u
X478 a_1548_4765# clk_feedback VSS VSS nfet_05v0 ad=0.2569p pd=1.56u as=0.2244p ps=1.9u w=0.51u l=0.6u
X479 a_6336_7124# a_2000_6296# a_6112_7124# VDD pfet_05v0 ad=0.196p pd=1.26u as=0.1736p ps=1.18u w=0.56u l=0.5u
X480 a_3444_3608# a_2176_4292# VDD VDD pfet_05v0 ad=0.3432p pd=2.44u as=0.45p ps=2.02u w=0.78u l=0.5u
X481 a_5130_2420# a_1324_4765# a_2936_3438# VDD pfet_05v0 ad=0.4087p pd=1.89u as=0.5368p ps=3.32u w=1.22u l=0.5u
X482 VDD a_8748_5079# a_8660_5176# VDD pfet_05v0 ad=0.5368p pd=3.32u as=0.5368p ps=3.32u w=1.22u l=1u
X483 a_6272_4059# a_5860_4472# VSS VSS nfet_05v0 ad=0.1782p pd=1.69u as=0.1053p ps=0.925u w=0.405u l=0.6u
X484 a_2116_9544# a_1020_7552# VSS VSS nfet_05v0 ad=0.1248p pd=1u as=0.2112p ps=1.84u w=0.48u l=0.6u
X485 a_2744_10700# a_4233_9040# VDD VDD pfet_05v0 ad=0.5346p pd=3.31u as=0.5346p ps=3.31u w=1.215u l=0.5u
X486 a_3568_7996# a_1044_7991# a_3256_7996# VSS nfet_05v0 ad=94.5f pd=0.885u as=0.2007p ps=1.475u w=0.36u l=0.6u
X487 a_1244_5512# a_1156_5556# VSS VSS nfet_05v0 ad=0.3608p pd=2.52u as=0.3608p ps=2.52u w=0.82u l=1u
X488 a_5185_9432# a_5457_9456# VSS VSS nfet_05v0 ad=93.59999f pd=0.88u as=0.2288p ps=1.58u w=0.36u l=0.6u
X489 VDD a_3708_6647# a_3620_6744# VDD pfet_05v0 ad=0.5368p pd=3.32u as=0.5368p ps=3.32u w=1.22u l=1u
X490 a_3256_2908# a_1044_2904# a_2316_2464# VDD pfet_05v0 ad=0.25375p pd=1.51u as=0.2424p ps=1.465u w=0.505u l=0.5u
X491 a_2380_4772# a_2000_6296# a_1548_4765# VSS nfet_05v0 ad=0.1312p pd=1.14u as=0.2569p ps=1.56u w=0.82u l=0.6u
X492 a_2116_9544# a_1020_7552# VDD VDD pfet_05v0 ad=0.3782p pd=1.84u as=0.5368p ps=3.32u w=1.22u l=0.5u
X493 a_5052_1943# a_4964_2040# VSS VSS nfet_05v0 ad=0.3608p pd=2.52u as=0.3608p ps=2.52u w=0.82u l=1u
X494 VSS a_796_1675# a_1044_2904# VSS nfet_05v0 ad=0.1053p pd=0.925u as=0.1782p ps=1.69u w=0.405u l=0.6u
X495 a_8524_9783# a_8436_9880# VSS VSS nfet_05v0 ad=0.3608p pd=2.52u as=0.3608p ps=2.52u w=0.82u l=1u
X496 a_796_9783# a_708_9880# VSS VSS nfet_05v0 ad=0.3608p pd=2.52u as=0.3608p ps=2.52u w=0.82u l=1u
X497 a_7973_7608# a_7721_6040# a_7779_7608# VSS nfet_05v0 ad=0.1722p pd=1.24u as=0.1517p ps=1.19u w=0.82u l=0.6u
X498 a_8300_5079# a_8212_5176# VSS VSS nfet_05v0 ad=0.3608p pd=2.52u as=0.3608p ps=2.52u w=0.82u l=1u
X499 VDD a_7964_10216# a_7876_10260# VDD pfet_05v0 ad=0.5368p pd=3.32u as=0.5368p ps=3.32u w=1.22u l=1u
X500 a_6832_5176# a_5500_6324# a_6628_5176# VDD pfet_05v0 ad=0.3782p pd=1.84u as=0.3172p ps=1.74u w=1.22u l=0.5u
X501 a_6844_10216# a_6756_10260# VSS VSS nfet_05v0 ad=0.3608p pd=2.52u as=0.3608p ps=2.52u w=0.82u l=1u
X502 a_7000_8312# a_2000_6296# a_7000_7908# VDD pfet_05v0 ad=0.5368p pd=3.32u as=0.3172p ps=1.74u w=1.22u l=0.5u
X503 VDD a_8377_9040# a_8272_9180# VDD pfet_05v0 ad=0.29465p pd=1.74u as=0.1313p ps=1.025u w=0.505u l=0.5u
X504 a_8377_2768# a_2176_4292# VDD VDD pfet_05v0 ad=0.26p pd=1.52u as=0.29465p ps=1.74u w=1u l=0.5u
X505 a_3568_2908# a_1456_2491# a_3256_2908# VDD pfet_05v0 ad=0.1313p pd=1.025u as=0.25375p ps=1.51u w=0.505u l=0.5u
X506 VDD a_8377_2768# a_8272_2908# VDD pfet_05v0 ad=0.29465p pd=1.74u as=0.1313p ps=1.025u w=0.505u l=0.5u
X507 a_6308_6744# a_4604_4495# a_6408_8736# VDD pfet_05v0 ad=0.44955p pd=1.955u as=0.3159p ps=1.735u w=1.215u l=0.5u
X508 a_8377_9040# a_7960_9180# a_8753_9180# VSS nfet_05v0 ad=0.176p pd=1.68u as=0.134p ps=1.1u w=0.4u l=0.6u
X509 a_7224_7908# cfg_divider[1] a_7000_7908# VSS nfet_05v0 ad=0.1312p pd=1.14u as=0.2132p ps=1.34u w=0.82u l=0.6u
X510 VSS a_2632_9502# a_1020_7552# VSS nfet_05v0 ad=0.1183p pd=0.975u as=0.1183p ps=0.975u w=0.455u l=0.6u
X511 VSS a_5500_6324# a_1324_4765# VSS nfet_05v0 ad=0.1209p pd=0.985u as=0.1209p ps=0.985u w=0.465u l=0.6u
X512 a_4604_6647# a_4516_6744# VSS VSS nfet_05v0 ad=0.3608p pd=2.52u as=0.3608p ps=2.52u w=0.82u l=1u
X513 a_3348_10260# a_2744_10700# VDD VDD pfet_05v0 ad=0.1456p pd=1.08u as=0.4005p ps=2.12u w=0.56u l=0.5u
X514 a_1548_9469# a_1096_6296# a_2120_6340# VSS nfet_05v0 ad=0.2132p pd=1.34u as=0.1312p ps=1.14u w=0.82u l=0.6u
X515 a_3548_3559# a_3240_3608# VSS VSS nfet_05v0 ad=0.2007p pd=1.475u as=0.2016p ps=1.48u w=0.36u l=0.6u
X516 VSS a_4828_3944# a_6404_6054# VSS nfet_05v0 ad=0.2486p pd=2.01u as=0.1469p ps=1.085u w=0.565u l=0.6u
X517 a_6916_8780# a_5748_9176# a_6712_8780# VDD pfet_05v0 ad=0.2028p pd=1.3u as=0.2028p ps=1.3u w=0.78u l=0.5u
X518 a_1096_6296# a_3561_7472# VSS VSS nfet_05v0 ad=0.3586p pd=2.51u as=0.3586p ps=2.51u w=0.815u l=0.6u
X519 a_2008_2508# a_1456_2491# a_1804_2508# VDD pfet_05v0 ad=0.2028p pd=1.3u as=0.2028p ps=1.3u w=0.78u l=0.5u
X520 VSS modulus_33 a_7748_4728# VSS nfet_05v0 ad=0.2112p pd=1.84u as=0.2112p ps=1.84u w=0.48u l=0.6u
X521 a_7000_7908# a_6328_8444# VSS VSS nfet_05v0 ad=0.2132p pd=1.34u as=0.218p ps=1.52u w=0.82u l=0.6u
X522 a_6916_2508# a_5748_2904# a_6712_2508# VDD pfet_05v0 ad=0.2028p pd=1.3u as=0.2028p ps=1.3u w=0.78u l=0.5u
X523 a_796_1675# a_2856_4798# VDD VDD pfet_05v0 ad=0.3782p pd=1.84u as=0.3782p ps=1.84u w=1.22u l=0.5u
X524 a_2364_8780# a_2264_8736# VSS VSS nfet_05v0 ad=93.59999f pd=0.88u as=0.1584p ps=1.6u w=0.36u l=0.6u
X525 VSS a_1020_7552# a_1044_7991# VSS nfet_05v0 ad=0.1053p pd=0.925u as=0.1782p ps=1.69u w=0.405u l=0.6u
X526 VSS a_5457_9456# a_8232_7864# VSS nfet_05v0 ad=0.1584p pd=1.6u as=93.59999f ps=0.88u w=0.36u l=0.6u
X527 a_1804_8312# a_1246_9880# VSS VSS nfet_05v0 ad=93.59999f pd=0.88u as=0.1584p ps=1.6u w=0.36u l=0.6u
X528 a_6408_2464# a_5500_6324# a_6600_3204# VSS nfet_05v0 ad=0.2132p pd=1.34u as=0.1312p ps=1.14u w=0.82u l=0.6u
X529 a_7268_3740# a_5500_6324# VDD VDD pfet_05v0 ad=0.1456p pd=1.08u as=0.4005p ps=2.12u w=0.56u l=0.5u
X530 a_8972_9783# a_8884_9880# VSS VSS nfet_05v0 ad=0.3608p pd=2.52u as=0.3608p ps=2.52u w=0.82u l=1u
X531 a_2296_2908# a_1456_2491# a_2008_2508# VSS nfet_05v0 ad=43.2f pd=0.6u as=93.59999f ps=0.88u w=0.36u l=0.6u
X532 a_7736_8312# cfg_divider[3] a_7924_8312# VDD pfet_05v0 ad=0.3172p pd=1.74u as=0.3172p ps=1.74u w=1.22u l=0.5u
X533 a_1672_2040# a_1120_2040# a_1468_2040# VDD pfet_05v0 ad=0.2028p pd=1.3u as=0.2028p ps=1.3u w=0.78u l=0.5u
X534 a_796_1675# a_2856_4798# VSS VSS nfet_05v0 ad=0.1183p pd=0.975u as=0.1183p ps=0.975u w=0.455u l=0.6u
X535 a_1344_7195# a_932_7608# VSS VSS nfet_05v0 ad=0.1782p pd=1.69u as=0.1053p ps=0.925u w=0.405u l=0.6u
X536 a_8188_1943# a_8100_2040# VSS VSS nfet_05v0 ad=0.3608p pd=2.52u as=0.3608p ps=2.52u w=0.82u l=1u
X537 a_6664_10012# a_2744_10700# VSS VSS nfet_05v0 ad=93.59999f pd=0.88u as=0.1584p ps=1.6u w=0.36u l=0.6u
X538 a_3584_9743# a_3696_5556# VSS VSS nfet_05v0 ad=0.1183p pd=0.975u as=0.2002p ps=1.79u w=0.455u l=0.6u
X539 VDD a_1096_6296# a_8879_6875# VDD pfet_05v0 ad=0.38705p pd=2.08u as=0.1469p ps=1.085u w=0.565u l=0.5u
X540 VSS a_3337_4336# a_3232_4476# VSS nfet_05v0 ad=0.1224p pd=1.04u as=94.5f ps=0.885u w=0.36u l=0.6u
X541 VSS cfg_divider[5] a_3080_6040# VSS nfet_05v0 ad=0.3608p pd=2.52u as=0.1312p ps=1.14u w=0.82u l=0.6u
X542 VDD a_3584_9743# a_2632_9502# VDD pfet_05v0 ad=0.3608p pd=2.52u as=0.2542p ps=1.44u w=0.82u l=0.5u
X543 a_6712_2508# a_5748_2904# a_6508_2508# VSS nfet_05v0 ad=93.59999f pd=0.88u as=93.59999f ps=0.88u w=0.36u l=0.6u
X544 a_1876_2040# rst_n VDD VDD pfet_05v0 ad=0.3432p pd=2.44u as=0.45p ps=2.02u w=0.78u l=0.5u
X545 a_5612_5512# a_5524_5556# VSS VSS nfet_05v0 ad=0.3608p pd=2.52u as=0.3608p ps=2.52u w=0.82u l=1u
X546 a_3456_7612# a_932_7608# a_3144_7612# VSS nfet_05v0 ad=94.5f pd=0.885u as=0.2007p ps=1.475u w=0.36u l=0.6u
X547 a_7280_4476# a_7132_4032# a_7112_4476# VSS nfet_05v0 ad=43.2f pd=0.6u as=43.2f ps=0.6u w=0.36u l=0.6u
X548 VDD a_2204_7168# a_2100_7212# VDD pfet_05v0 ad=0.45p pd=2.02u as=0.2028p ps=1.3u w=0.78u l=0.5u
X549 a_7639_6362# a_5724_6324# a_8071_6744# VDD pfet_05v0 ad=0.3159p pd=1.735u as=0.37665p ps=1.835u w=1.215u l=0.5u
X550 a_3696_5556# clk_prescaled VSS VSS nfet_05v0 ad=0.2662p pd=2.09u as=0.2662p ps=2.09u w=0.605u l=0.6u
X551 VSS cfg_divider[4] a_8331_6362# VSS nfet_05v0 ad=0.3124p pd=2.3u as=85.2f ps=0.95u w=0.71u l=0.6u
X552 VDD a_1020_7552# a_1044_7991# VDD pfet_05v0 ad=0.2249p pd=1.385u as=0.3806p ps=2.61u w=0.865u l=0.5u
X553 a_2680_10744# a_1806_10260# VSS VSS nfet_05v0 ad=0.1312p pd=1.14u as=0.3608p ps=2.52u w=0.82u l=0.6u
X554 a_6520_4032# a_7748_4728# a_7600_5176# VDD pfet_05v0 ad=0.3159p pd=1.735u as=0.44955p ps=1.955u w=1.215u l=0.5u
X555 a_4128_9180# a_2016_8763# a_3816_9180# VDD pfet_05v0 ad=0.1313p pd=1.025u as=0.25375p ps=1.51u w=0.505u l=0.5u
X556 VDD a_6888_3160# a_6392_3608# VDD pfet_05v0 ad=0.4005p pd=2.12u as=0.3172p ps=1.74u w=1.22u l=0.5u
X557 VSS a_2444_4728# a_2380_4772# VSS nfet_05v0 ad=0.3608p pd=2.52u as=0.1312p ps=1.14u w=0.82u l=0.6u
X558 a_6112_7124# a_2744_10700# a_5888_7124# VDD pfet_05v0 ad=0.1736p pd=1.18u as=0.1736p ps=1.18u w=0.56u l=0.5u
X559 VSS a_3337_1680# a_3232_1724# VSS nfet_05v0 ad=0.1224p pd=1.04u as=94.5f ps=0.885u w=0.36u l=0.6u
X560 VDD a_5276_5079# a_5188_5176# VDD pfet_05v0 ad=0.5368p pd=3.32u as=0.5368p ps=3.32u w=1.22u l=1u
X561 a_7537_6040# a_4828_3944# VSS VSS nfet_05v0 ad=0.1304p pd=1.135u as=0.3586p ps=2.51u w=0.815u l=0.6u
X562 VDD a_796_10216# a_708_10260# VDD pfet_05v0 ad=0.5368p pd=3.32u as=0.5368p ps=3.32u w=1.22u l=1u
X563 a_1120_2040# a_708_1719# VSS VSS nfet_05v0 ad=0.1782p pd=1.69u as=0.1053p ps=0.925u w=0.405u l=0.6u
X564 a_1672_4076# a_1120_4059# a_1468_4076# VDD pfet_05v0 ad=0.2028p pd=1.3u as=0.2028p ps=1.3u w=0.78u l=0.5u
X565 a_2008_8312# a_1456_8312# a_1804_8312# VDD pfet_05v0 ad=0.2028p pd=1.3u as=0.2028p ps=1.3u w=0.78u l=0.5u
X566 a_1704_2464# a_3337_1680# VSS VSS nfet_05v0 ad=0.3586p pd=2.51u as=0.3586p ps=2.51u w=0.815u l=0.6u
X567 a_3673_2768# rst_n VDD VDD pfet_05v0 ad=0.26p pd=1.52u as=0.29465p ps=1.74u w=1u l=0.5u
X568 VDD a_796_5079# a_708_5176# VDD pfet_05v0 ad=0.5368p pd=3.32u as=0.5368p ps=3.32u w=1.22u l=1u
X569 VDD a_796_1675# a_5748_2904# VDD pfet_05v0 ad=0.2249p pd=1.385u as=0.3806p ps=2.61u w=0.865u l=0.5u
X570 a_6408_2464# a_6404_6054# a_6392_3608# VDD pfet_05v0 ad=0.3172p pd=1.74u as=0.5368p ps=3.32u w=1.22u l=0.5u
X571 VDD a_5457_9456# a_4956_7909# VDD pfet_05v0 ad=0.4972p pd=3.14u as=0.4012p ps=1.85u w=1.13u l=0.5u
X572 a_1876_4076# a_2176_4292# VDD VDD pfet_05v0 ad=0.3432p pd=2.44u as=0.45p ps=2.02u w=0.78u l=0.5u
X573 a_6712_8780# a_5748_9176# a_6508_8780# VSS nfet_05v0 ad=93.59999f pd=0.88u as=93.59999f ps=0.88u w=0.36u l=0.6u
X574 a_1692_3511# a_1604_3608# VSS VSS nfet_05v0 ad=0.3608p pd=2.52u as=0.3608p ps=2.52u w=0.82u l=1u
X575 a_2772_8780# a_1604_9176# a_2568_8780# VDD pfet_05v0 ad=0.2028p pd=1.3u as=0.2028p ps=1.3u w=0.78u l=0.5u
X576 a_4609_9180# a_2176_4292# VSS VSS nfet_05v0 ad=0.134p pd=1.1u as=0.1224p ps=1.04u w=0.36u l=0.6u
X577 VDD a_4604_1943# a_4516_2040# VDD pfet_05v0 ad=0.5368p pd=3.32u as=0.5368p ps=3.32u w=1.22u l=1u
X578 a_8612_8444# cfg_divider[3] VDD VDD pfet_05v0 ad=0.1456p pd=1.08u as=0.4005p ps=2.12u w=0.56u l=0.5u
X579 a_4049_7996# a_2176_4292# VSS VSS nfet_05v0 ad=0.134p pd=1.1u as=0.1224p ps=1.04u w=0.36u l=0.6u
X580 a_1692_7212# a_1216_6340# VSS VSS nfet_05v0 ad=93.59999f pd=0.88u as=0.1584p ps=1.6u w=0.36u l=0.6u
X581 a_8272_2908# a_5748_2904# a_7960_2908# VSS nfet_05v0 ad=94.5f pd=0.885u as=0.2007p ps=1.475u w=0.36u l=0.6u
X582 VDD a_7020_8736# a_6916_8780# VDD pfet_05v0 ad=0.45p pd=2.02u as=0.2028p ps=1.3u w=0.78u l=0.5u
X583 a_2212_2508# a_1044_2904# a_2008_2508# VDD pfet_05v0 ad=0.2028p pd=1.3u as=0.2028p ps=1.3u w=0.78u l=0.5u
X584 VDD a_7020_2464# a_6916_2508# VDD pfet_05v0 ad=0.45p pd=2.02u as=0.2028p ps=1.3u w=0.78u l=0.5u
X585 VSS a_1548_4765# a_1246_5176# VSS nfet_05v0 ad=0.2486p pd=2.01u as=0.1469p ps=1.085u w=0.565u l=0.6u
X586 a_2856_5556# a_2184_5556# VDD VDD pfet_05v0 ad=0.3172p pd=1.74u as=0.4005p ps=2.12u w=1.22u l=0.5u
X587 a_1020_7552# a_2632_9502# VSS VSS nfet_05v0 ad=0.1183p pd=0.975u as=0.2002p ps=1.79u w=0.455u l=0.6u
X588 VSS a_5508_7564# a_4604_4495# VSS nfet_05v0 ad=0.218p pd=1.52u as=0.3608p ps=2.52u w=0.82u l=0.6u
X589 a_4905_3248# a_4488_3292# a_5281_3292# VSS nfet_05v0 ad=0.176p pd=1.68u as=0.134p ps=1.1u w=0.4u l=0.6u
X590 VDD a_5508_7564# a_4604_4495# VDD pfet_05v0 ad=0.389p pd=2.02u as=0.5368p ps=3.32u w=1.22u l=0.5u
X591 VSS a_1324_4765# a_6408_8736# VSS nfet_05v0 ad=0.2244p pd=1.9u as=0.2569p ps=1.56u w=0.51u l=0.6u
X592 a_7292_1943# a_7204_2040# VSS VSS nfet_05v0 ad=0.3608p pd=2.52u as=0.3608p ps=2.52u w=0.82u l=1u
X593 a_3528_3292# a_2688_3608# a_3240_3608# VSS nfet_05v0 ad=43.2f pd=0.6u as=93.59999f ps=0.88u w=0.36u l=0.6u
X594 a_5208_3988# a_4604_4495# a_5208_4472# VDD pfet_05v0 ad=0.5368p pd=3.32u as=0.3172p ps=1.74u w=1.22u l=0.5u
X595 a_5457_9456# a_8377_9040# VSS VSS nfet_05v0 ad=0.3586p pd=2.51u as=0.3586p ps=2.51u w=0.815u l=0.6u
X596 a_2408_6296# a_2000_6296# a_2788_6876# VDD pfet_05v0 ad=0.2464p pd=2u as=0.1456p ps=1.08u w=0.56u l=0.5u
X597 VDD a_5612_10216# a_5524_10260# VDD pfet_05v0 ad=0.5368p pd=3.32u as=0.5368p ps=3.32u w=1.22u l=1u
X598 a_6844_7080# a_6756_7124# VSS VSS nfet_05v0 ad=0.3608p pd=2.52u as=0.3608p ps=2.52u w=0.82u l=1u
X599 a_6824_4076# a_6272_4059# a_6620_4076# VDD pfet_05v0 ad=0.2028p pd=1.3u as=0.2028p ps=1.3u w=0.78u l=0.5u
X600 VSS a_2176_4292# a_7168_2908# VSS nfet_05v0 ad=0.2016p pd=1.48u as=43.2f ps=0.6u w=0.36u l=0.6u
X601 VSS a_2744_10700# a_5185_9432# VSS nfet_05v0 ad=0.1584p pd=1.6u as=93.59999f ps=0.88u w=0.36u l=0.6u
X602 a_1980_4032# a_1672_4076# VDD VDD pfet_05v0 ad=0.2424p pd=1.465u as=0.2222p ps=1.89u w=0.505u l=0.5u
X603 VDD a_2856_4798# a_796_1675# VDD pfet_05v0 ad=0.3782p pd=1.84u as=0.3782p ps=1.84u w=1.22u l=0.5u
X604 a_7924_8312# cfg_divider[3] a_7944_7908# VSS nfet_05v0 ad=0.2132p pd=1.34u as=0.1312p ps=1.14u w=0.82u l=0.6u
X605 a_1980_4032# a_1672_4076# VSS VSS nfet_05v0 ad=0.2007p pd=1.475u as=0.2016p ps=1.48u w=0.36u l=0.6u
X606 VDD a_1020_7552# a_2116_9544# VDD pfet_05v0 ad=0.5368p pd=3.32u as=0.3782p ps=1.84u w=1.22u l=0.5u
X607 a_6160_8763# a_5748_9176# VSS VSS nfet_05v0 ad=0.1782p pd=1.69u as=0.1053p ps=0.925u w=0.405u l=0.6u
X608 a_3256_2908# a_1456_2491# a_2316_2464# VSS nfet_05v0 ad=0.2007p pd=1.475u as=0.2007p ps=1.475u w=0.36u l=0.6u
X609 VSS a_2632_9502# a_1020_7552# VSS nfet_05v0 ad=0.2002p pd=1.79u as=0.1183p ps=0.975u w=0.455u l=0.6u
X610 a_7028_4076# a_2176_4292# VDD VDD pfet_05v0 ad=0.3432p pd=2.44u as=0.45p ps=2.02u w=0.78u l=0.5u
X611 VDD a_796_1675# a_5860_4472# VDD pfet_05v0 ad=0.2249p pd=1.385u as=0.3806p ps=2.61u w=0.865u l=0.5u
X612 VSS a_1020_7552# a_932_7608# VSS nfet_05v0 ad=0.1053p pd=0.925u as=0.1782p ps=1.69u w=0.405u l=0.6u
X613 a_8331_6362# a_5724_6324# a_7639_6362# VSS nfet_05v0 ad=85.2f pd=0.95u as=0.21175p ps=1.41u w=0.71u l=0.6u
X614 a_3673_7952# a_3256_7996# a_4049_7996# VSS nfet_05v0 ad=0.176p pd=1.68u as=0.134p ps=1.1u w=0.4u l=0.6u
X615 a_8272_9180# a_5748_9176# a_7960_9180# VSS nfet_05v0 ad=94.5f pd=0.885u as=0.2007p ps=1.475u w=0.36u l=0.6u
X616 a_9308_10216# a_9220_10260# VSS VSS nfet_05v0 ad=0.3608p pd=2.52u as=0.3608p ps=2.52u w=0.82u l=1u
X617 VDD a_4604_9783# a_4516_9880# VDD pfet_05v0 ad=0.5368p pd=3.32u as=0.5368p ps=3.32u w=1.22u l=1u
X618 a_9196_5079# a_9108_5176# VSS VSS nfet_05v0 ad=0.3608p pd=2.52u as=0.3608p ps=2.52u w=0.82u l=1u
X619 VDD a_4604_6647# a_4516_6744# VDD pfet_05v0 ad=0.5368p pd=3.32u as=0.5368p ps=3.32u w=1.22u l=1u
X620 a_6508_2508# a_6408_2464# VSS VSS nfet_05v0 ad=93.59999f pd=0.88u as=0.1584p ps=1.6u w=0.36u l=0.6u
X621 VDD a_4380_5079# a_4292_5176# VDD pfet_05v0 ad=0.5368p pd=3.32u as=0.5368p ps=3.32u w=1.22u l=1u
X622 a_5164_10216# a_5076_10260# VSS VSS nfet_05v0 ad=0.3608p pd=2.52u as=0.3608p ps=2.52u w=0.82u l=1u
X623 a_2688_3608# a_2276_3287# VDD VDD pfet_05v0 ad=0.3806p pd=2.61u as=0.2249p ps=1.385u w=0.865u l=0.5u
X624 a_2212_8312# a_1044_7991# a_2008_8312# VDD pfet_05v0 ad=0.2028p pd=1.3u as=0.2028p ps=1.3u w=0.78u l=0.5u
X625 VDD a_9084_8215# a_8996_8312# VDD pfet_05v0 ad=0.5368p pd=3.32u as=0.5368p ps=3.32u w=1.22u l=1u
X626 a_1980_1991# a_1672_2040# VSS VSS nfet_05v0 ad=0.2007p pd=1.475u as=0.2016p ps=1.48u w=0.36u l=0.6u
X627 a_2264_8736# a_2744_10700# a_2680_10744# VSS nfet_05v0 ad=0.2132p pd=1.34u as=0.1312p ps=1.14u w=0.82u l=0.6u
X628 a_3816_9180# a_2016_8763# a_2876_8736# VSS nfet_05v0 ad=0.2007p pd=1.475u as=0.2007p ps=1.475u w=0.36u l=0.6u
X629 VSS a_2176_4292# a_7168_9180# VSS nfet_05v0 ad=0.2016p pd=1.48u as=43.2f ps=0.6u w=0.36u l=0.6u
X630 VDD a_796_1675# a_1044_2904# VDD pfet_05v0 ad=0.2249p pd=1.385u as=0.3806p ps=2.61u w=0.865u l=0.5u
X631 a_6160_2491# a_5748_2904# VDD VDD pfet_05v0 ad=0.3806p pd=2.61u as=0.2249p ps=1.385u w=0.865u l=0.5u
X632 VSS a_5724_6324# a_2444_4728# VSS nfet_05v0 ad=0.1584p pd=1.6u as=93.59999f ps=0.88u w=0.36u l=0.6u
X633 a_4724_3988# a_4604_4495# a_4536_3988# VDD pfet_05v0 ad=0.1456p pd=1.08u as=0.2464p ps=2u w=0.56u l=0.5u
X634 VDD a_3584_9743# a_2856_4798# VDD pfet_05v0 ad=0.3608p pd=2.52u as=0.2542p ps=1.44u w=0.82u l=0.5u
X635 VSS a_5185_9432# a_5052_6324# VSS nfet_05v0 ad=0.2288p pd=1.58u as=0.3608p ps=2.52u w=0.82u l=0.6u
X636 a_2008_8312# a_1044_7991# a_1804_8312# VSS nfet_05v0 ad=93.59999f pd=0.88u as=93.59999f ps=0.88u w=0.36u l=0.6u
X637 a_3937_7612# a_2176_4292# VSS VSS nfet_05v0 ad=0.134p pd=1.1u as=0.1224p ps=1.04u w=0.36u l=0.6u
X638 a_9308_5512# a_9220_5556# VSS VSS nfet_05v0 ad=0.3608p pd=2.52u as=0.3608p ps=2.52u w=0.82u l=1u
.ends E03_ble_feedback_divider
