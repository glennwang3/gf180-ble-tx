* E03_PLL_BIAS: LVS reference of GDS cell E03_PLL_BIAS (from PLL_BIAS.spice, subckt PLL_BIAS)
.subckt E03_PLL_BIAS VDD VSS IBIAS TAIL_BIAS
XMTD_0 TAIL_BIAS TAIL_BIAS VSS VSS nfet_03v3 w=1u l=5.6u
XMPD_0 PG PG VDD VDD pfet_03v3 w=4u l=2u
XMCP0_0 CPM PG VDD VDD pfet_03v3 w=1.04u l=5u
XMCP1_0 IBIAS PG CPM VDD pfet_03v3 w=1.04u l=5u
XMT_0 TAIL_BIAS PG VDD VDD pfet_03v3 w=4u l=2u
XRREF_0 PG RREF_n1 VSS ppolyf_u_1k r_width=1u r_length=18.6u
XRREF_1 RREF_n1 RREF_n2 VSS ppolyf_u_1k r_width=1u r_length=18.6u
XRREF_2 RREF_n2 RREF_n3 VSS ppolyf_u_1k r_width=1u r_length=18.6u
XRREF_3 RREF_n3 RREF_n4 VSS ppolyf_u_1k r_width=1u r_length=18.6u
XRREF_4 RREF_n4 RREF_n5 VSS ppolyf_u_1k r_width=1u r_length=18.6u
XRREF_5 RREF_n5 RREF_n6 VSS ppolyf_u_1k r_width=1u r_length=18.6u
XRREF_6 RREF_n6 RREF_n7 VSS ppolyf_u_1k r_width=1u r_length=18.6u
XRREF_7 RREF_n7 RREF_n8 VSS ppolyf_u_1k r_width=1u r_length=18.6u
XRREF_8 RREF_n8 RREF_n9 VSS ppolyf_u_1k r_width=1u r_length=18.6u
XRREF_9 RREF_n9 VSS VSS ppolyf_u_1k r_width=1u r_length=18.6u
XCT0 TAIL_BIAS VSS cap_nmos_03v3 c_width=20u c_length=6u
XCT1 TAIL_BIAS VSS cap_nmos_03v3 c_width=20u c_length=6u
XCT2 TAIL_BIAS VSS cap_nmos_03v3 c_width=20u c_length=6u
.ends E03_PLL_BIAS
