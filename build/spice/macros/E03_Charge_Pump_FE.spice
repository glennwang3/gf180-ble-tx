* E03_Charge_Pump_FE: LVS reference of GDS cell E03_Charge_Pump_FE (from M_pump.spice, subckt M_pump)
* NGSPICE file created from M_pump.ext - technology: gf180mcuE

.subckt E03_Charge_Pump_FE VDD VSS UPb DN IBIAS OUT P_BIAS
X0 P_BIAS IBIAS a_n712_n618# VSS nfet_03v3 ad=0.728p pd=3.54u as=0.224p ps=1.68u w=1.12u l=1u
X1 a_436_320# P_BIAS OUT VDD pfet_03v3 ad=0.448p pd=2.8u as=1.5456p ps=5.86u w=2.24u l=1u
X2 IBIAS IBIAS a_n62_n618# VSS nfet_03v3 ad=0.728p pd=3.54u as=0.224p ps=1.68u w=1.12u l=1u
X3 a_n62_n618# VDD VSS VSS nfet_03v3 ad=0.224p pd=1.68u as=0.3304p ps=2.3u w=0.56u l=0.28u
X4 VDD VSS a_n824_320# VDD pfet_03v3 ad=0.728p pd=3.54u as=0.448p ps=2.8u w=1.12u l=0.28u
X5 VDD UPb a_436_320# VDD pfet_03v3 ad=0.728p pd=3.54u as=0.448p ps=2.8u w=1.12u l=0.28u
X6 a_548_n618# DN VSS VSS nfet_03v3 ad=0.224p pd=1.68u as=0.3304p ps=2.3u w=0.56u l=0.28u
X7 a_n824_320# P_BIAS P_BIAS VDD pfet_03v3 ad=0.448p pd=2.8u as=1.5456p ps=5.86u w=2.24u l=1u
X8 a_n712_n618# VDD VSS VSS nfet_03v3 ad=0.224p pd=1.68u as=0.3304p ps=2.3u w=0.56u l=0.28u
X9 OUT IBIAS a_548_n618# VSS nfet_03v3 ad=0.728p pd=3.54u as=0.224p ps=1.68u w=1.12u l=1u
.ends E03_Charge_Pump_FE
