* E03_Phase_Detector_FE: LVS reference of GDS cell E03_Phase_Detector_FE (from M_pfd.spice, subckt M_pfd)
* NGSPICE file created from M_pfd.ext - technology: gf180mcuE

.subckt E03_Phase_Detector_FE VDD VSS F_REF UP DN F_VCO UPb DNb N_DN N_UP
X0 VDD F_VCO UPb VDD pfet_03v3 ad=0.728p pd=3.54u as=0.728p ps=3.54u w=1.12u l=0.28u
X1 DNb UP N_DN VSS nfet_03v3 ad=0.3416p pd=2.34u as=0.3416p ps=2.34u w=0.56u l=0.28u
X2 UP UPb VSS VSS nfet_03v3 ad=0.3416p pd=2.34u as=0.3416p ps=2.34u w=0.56u l=0.28u
X3 VDD UPb UP VDD pfet_03v3 ad=0.728p pd=3.54u as=0.728p ps=3.54u w=1.12u l=0.28u
X4 N_UP F_VCO VSS VSS nfet_03v3 ad=0.1456p pd=1.08u as=0.3416p ps=2.34u w=0.56u l=0.28u
X5 UPb F_REF N_UP VSS nfet_03v3 ad=0.3416p pd=2.34u as=0.1456p ps=1.08u w=0.56u l=0.28u
X6 N_DN F_REF VSS VSS nfet_03v3 ad=0.1456p pd=1.08u as=0.3416p ps=2.34u w=0.56u l=0.28u
X7 VDD F_REF DNb VDD pfet_03v3 ad=0.728p pd=3.54u as=0.728p ps=3.54u w=1.12u l=0.28u
X8 VDD DNb DN VDD pfet_03v3 ad=0.728p pd=3.54u as=0.728p ps=3.54u w=1.12u l=0.28u
X9 DNb F_VCO N_DN VSS nfet_03v3 ad=0.3416p pd=2.34u as=0.1456p ps=1.08u w=0.56u l=0.28u
X10 UPb DN N_UP VSS nfet_03v3 ad=0.3416p pd=2.34u as=0.3416p ps=2.34u w=0.56u l=0.28u
X11 DN DNb VSS VSS nfet_03v3 ad=0.3416p pd=2.34u as=0.3416p ps=2.34u w=0.56u l=0.28u
.ends E03_Phase_Detector_FE
