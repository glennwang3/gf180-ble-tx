* E03_Differential_VCO_LC: LVS reference of GDS cell E03_Differential_VCO_LC (from ref_lc.spice, subckt Differential_VCO_LC)
* NGSPICE file created from Differential_VCO.ext - technology: gf180mcuE

.subckt E03_Differential_VCO_LC VTUNE VDD VSS O1P O1N O2N O3N O4P O4N DOUBLER_K MIM_TOP VBUF_DOUBLER VBUF_DIFF RF_DRV1 TAIL_BIAS CORE_CLK O2P O3P
X0 a_n4939_1760# MIM_TOP VSS ppolyf_u r_width=0.8u r_length=6.705u
X1 VDD O4P O2P VDD pfet_03v3 ad=1.95p pd=7.3u as=1.95p ps=7.3u w=3u l=0.28u
X2 VBUF_DIFF a_n2218_3378# CORE_CLK VBUF_DIFF pfet_03v3 ad=2.6p pd=9.3u as=2.6p ps=9.3u w=4u l=0.28u
X3 VSS O4N O1P VSS nfet_03v3 ad=0.915p pd=4.22u as=0.915p ps=4.22u w=1.5u l=0.28u
X4 a_n866_2740# TAIL_BIAS VSS VSS nfet_03v3 ad=0.61p pd=3.22u as=0.61p ps=3.22u w=1u l=0.28u
X5 RF_DRV1 MIM_TOP VSS VSS nfet_03v3 ad=0.61p pd=3.22u as=0.61p ps=3.22u w=1u l=0.28u
X6 a_n4939_n460# a_n3466_n200# VSS ppolyf_u r_width=0.8u r_length=6.705u
D0 O1P DOUBLER_K sc_diode pj=3.24u area=0.62p
X8 VDD O2P O4N VDD pfet_03v3 ad=1.95p pd=7.3u as=1.95p ps=7.3u w=3u l=0.28u
X9 a_n4939_2280# RF_DRV1 VSS ppolyf_u r_width=0.8u r_length=6.705u
X10 O3N O3P VSS VSS nfet_03v3 ad=0.4697p pd=2.76u as=0.4697p ps=2.76u w=0.77u l=0.28u
X11 VTUNE O4N cap_nmos_03v3 c_width=1u c_length=1u
X12 O2N O1N VSS VSS nfet_03v3 ad=0.915p pd=4.22u as=0.915p ps=4.22u w=1.5u l=0.28u
X13 VBUF_DIFF a_n1134_3368# a_n1134_3368# VBUF_DIFF pfet_03v3 ad=1.3p pd=5.3u as=1.3p ps=5.3u w=2u l=0.28u
X14 VTUNE O1P cap_nmos_03v3 c_width=1u c_length=1u
X15 O3N O1P VDD VDD pfet_03v3 ad=1.95p pd=7.3u as=1.95p ps=7.3u w=3u l=0.28u
X16 a_n4939_1760# a_n3466_2020# VSS ppolyf_u r_width=0.8u r_length=6.705u
X17 VBUF_DIFF a_n1134_3368# a_n2218_3378# VBUF_DIFF pfet_03v3 ad=1.3p pd=5.3u as=1.3p ps=5.3u w=2u l=0.28u
X18 O3N O2N VSS VSS nfet_03v3 ad=0.915p pd=4.22u as=0.915p ps=4.22u w=1.5u l=0.28u
X19 MIM_TOP DOUBLER_K cap_mim_2f0_m5m6_noshield c_width=5u c_length=5u
X20 CORE_CLK a_n2218_3378# VSS VSS nfet_03v3 ad=1.22p pd=5.22u as=1.22p ps=5.22u w=2u l=0.28u
X21 a_n4939_n460# VSS VSS ppolyf_u r_width=0.8u r_length=6.705u
X22 O1N O4P VSS VSS nfet_03v3 ad=0.915p pd=4.22u as=0.915p ps=4.22u w=1.5u l=0.28u
X23 VSS O1P O2P VSS nfet_03v3 ad=0.915p pd=4.22u as=0.915p ps=4.22u w=1.5u l=0.28u
X24 VTUNE O2N cap_nmos_03v3 c_width=1u c_length=1u
X26 VTUNE O3P cap_nmos_03v3 c_width=1u c_length=1u
X27 O4P O3P VSS VSS nfet_03v3 ad=0.915p pd=4.22u as=0.915p ps=4.22u w=1.5u l=0.28u
X29 O1N O3N VDD VDD pfet_03v3 ad=1.95p pd=7.3u as=1.95p ps=7.3u w=3u l=0.28u
X30 VSS O4P O4N VSS nfet_03v3 ad=0.4697p pd=2.76u as=0.4697p ps=2.76u w=0.77u l=0.28u
X31 O4P O4N VSS VSS nfet_03v3 ad=0.4697p pd=2.76u as=0.4697p ps=2.76u w=0.77u l=0.28u
X32 a_n4939_60# a_n3466_n200# VSS ppolyf_u r_width=0.8u r_length=6.705u
D1 O1N DOUBLER_K sc_diode pj=3.24u area=0.62p
X33 VSS O3N O4N VSS nfet_03v3 ad=0.915p pd=4.22u as=0.915p ps=4.22u w=1.5u l=0.28u
X34 VSS O2N O2P VSS nfet_03v3 ad=0.4697p pd=2.76u as=0.4697p ps=2.76u w=0.77u l=0.28u
X35 a_n2218_3378# O1P a_n866_2740# VSS nfet_03v3 ad=0.61p pd=3.22u as=0.61p ps=3.22u w=1u l=0.28u
X36 VTUNE O1N cap_nmos_03v3 c_width=1u c_length=1u
X37 VBUF_DOUBLER MIM_TOP RF_DRV1 VBUF_DOUBLER pfet_03v3 ad=1.3p pd=5.3u as=1.3p ps=5.3u w=2u l=0.28u
X38 O1N O1P VSS VSS nfet_03v3 ad=0.4697p pd=2.76u as=0.4697p ps=2.76u w=0.77u l=0.28u
X39 a_n1134_3368# O1N a_n866_2740# VSS nfet_03v3 ad=0.61p pd=3.22u as=0.61p ps=3.22u w=1u l=0.28u
X40 VSS O2P O3P VSS nfet_03v3 ad=0.915p pd=4.22u as=0.915p ps=4.22u w=1.5u l=0.28u
X42 VDD O1N O3P VDD pfet_03v3 ad=1.95p pd=7.3u as=1.95p ps=7.3u w=3u l=0.28u
X43 VSS O1N O1P VSS nfet_03v3 ad=0.4697p pd=2.76u as=0.4697p ps=2.76u w=0.77u l=0.28u
X44 a_n4939_2280# a_n3466_2020# VSS ppolyf_u r_width=0.8u r_length=6.705u
X45 VTUNE O2P cap_nmos_03v3 c_width=1u c_length=1u
X46 O4P O2N VDD VDD pfet_03v3 ad=1.95p pd=7.3u as=1.95p ps=7.3u w=3u l=0.28u
X47 a_n4939_60# DOUBLER_K VSS ppolyf_u r_width=0.8u r_length=6.705u
X48 VDD O3P O1P VDD pfet_03v3 ad=1.95p pd=7.3u as=1.95p ps=7.3u w=3u l=0.28u
X49 VTUNE O3N cap_nmos_03v3 c_width=1u c_length=1u
X50 VTUNE O4P cap_nmos_03v3 c_width=1u c_length=1u
X51 O2N O4N VDD VDD pfet_03v3 ad=1.95p pd=7.3u as=1.95p ps=7.3u w=3u l=0.28u
X52 VSS O3N O3P VSS nfet_03v3 ad=0.4697p pd=2.76u as=0.4697p ps=2.76u w=0.77u l=0.28u
X53 O2N O2P VSS VSS nfet_03v3 ad=0.4697p pd=2.76u as=0.4697p ps=2.76u w=0.77u l=0.28u
.ends E03_Differential_VCO_LC
