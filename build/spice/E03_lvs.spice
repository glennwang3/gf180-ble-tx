* E03 top-level LVS reference (PLL_COMPACT renamed for the tapeout; pads: VDD->vdd, VSS->vss, RST_N->reset_n, CLK_8M->clk, UART_RX->Tx, PA_DRAIN->ANT).
* Macro subckts: macros/*.spice, all listed in lvs_config.json LVS_SPICE_FILES.
.subckt E03 AIR_BIT CFG[0] CFG[1] CFG[2] CFG[3] CFG[4] CFG[5] clk CODE_VALID CORE_CLK CP_IBIAS DN FB_1M FINE_CODE[0] FINE_CODE[1] FINE_CODE[2] FINE_CODE[3] FINE_CODE[4] FINE_CODE[5] FINE_CODE[6] FINE_CODE[7] MC ANT PRESCALED REF_1M RF_DRV1 reset_n SYM_STROBE TAIL_BIAS Tx UPB VCTRL vdd VDD_VCO vss VTUNE
Xprescaler CORE_CLK prescaler_Q2 prescaler_X1_N1 prescaler_X2_N1 prescaler_Q3 prescaler_X3_N1 prescaler_X5_N1 prescaler_X4_N1 MC prescaler_NOR_OUT prescaler_Q4b prescaler_Q3n prescaler_Q5b PRESCALED prescaler_X1_N2 prescaler_X2_N2 prescaler_X3_N2 prescaler_Q1 prescaler_X6_DYN prescaler_NOR_PSTACK prescaler_X5_N2 prescaler_X4_N2 vdd vss E03_32_33_Complete_Prescaler
Xdivider vdd vss CFG[0] CFG[3] CFG[4] CFG[5] FB_1M PRESCALED MC CFG[1] CFG[2] reset_n E03_ble_feedback_divider
Xpfd vdd vss REF_1M pfd_UP DN FB_1M UPB pfd_DNb pfd_N_DN pfd_N_UP E03_Phase_Detector_FE
Xpump vdd vss UPB DN CP_IBIAS VCTRL pump_P_BIAS E03_Charge_Pump_FE
Xtx vdd vss AIR_BIT clk CODE_VALID reset_n SYM_STROBE FINE_CODE[0] FINE_CODE[1] FINE_CODE[2] FINE_CODE[3] FINE_CODE[4] FINE_CODE[5] FINE_CODE[6] FINE_CODE[7] Tx E03_ble_tx_uart
Xvco VTUNE VDD_VCO vss vco_O1P vco_O1N vco_O2N vco_O3N vco_O4P vco_O4N vco_DOUBLER_K vco_MIM_TOP vdd vdd RF_DRV1 TAIL_BIAS CORE_CLK vco_O2P vco_O3P E03_Differential_VCO_LC
Xreg vdd VCTRL VDD_VCO vss E03_VCO_REG_L
Xlf VCTRL vss lf_LF_RZ E03_PLL_LF_L
Xchain RF_DRV1 vdd vss ANT chain_D1 E03_RF_CHAIN_PA
Xbias vdd vss CP_IBIAS TAIL_BIAS E03_PLL_BIAS
.ends E03
