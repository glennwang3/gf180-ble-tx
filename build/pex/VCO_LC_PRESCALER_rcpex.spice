* NGSPICE file created from PLL_PEX.ext - technology: gf180mcuE

.subckt PLL_PEX RF_OUT TAIL_BIAS VTUNE VDD_VCO VSS VDD CORE_CLK PRESCALED MC O1P O1N
+ O2N O3N O4P O4N DOUBLER_K MIM_TOP O2P O3P
X0 O3N.t0 O1P.t5 VDD_VCO.t3 VDD_VCO.t2 pfet_03v3 ad=1.95p pd=7.3u as=1.95p ps=7.3u w=3u l=0.28u
X1 O1N.t2 O4P.t6 VSS.t69 VSS.t68 nfet_03v3 ad=0.915p pd=4.22u as=0.915p ps=4.22u w=1.5u l=0.28u
X2 a_73893_31864.t1 a_73225_31738.t4 a_73893_31678.t1 VDD.t26 pfet_03v3 ad=0.2912p pd=1.64u as=0.728p ps=3.54u w=1.12u l=0.28u
X3 a_74407_33724.t0 a_74347_33668.t2 a_73597_33018.t0 VSS.t66 nfet_03v3 ad=0.1456p pd=1.08u as=0.3416p ps=2.34u w=0.56u l=0.28u
X4 VDD.t20 a_80362_35700.t1 a_80362_35700.t2 VDD.t19 pfet_03v3 ad=1.3p pd=5.3u as=1.3p ps=5.3u w=2u l=0.28u
X5 a_70530_32714.t0 CORE_CLK.t10 VDD.t7 VDD.t6 pfet_03v3 ad=0.1872p pd=1.24u as=0.468p ps=2.74u w=0.72u l=0.32u
X6 a_76557_34092.t1 a_78030_34352.t1 VSS.t25 ppolyf_u r_width=0.8u r_length=6.705u
X7 VSS.t30 MC.t0 a_70565_34084.t0 VSS.t29 nfet_03v3 ad=0.228p pd=1.98u as=93.59999f ps=0.88u w=0.36u l=0.32u
X8 VSS.t60 a_70505_33852.t5 a_74347_33668.t1 VSS.t59 nfet_03v3 ad=0.3416p pd=2.34u as=0.3416p ps=2.34u w=0.56u l=0.28u
X9 O2N.t2 O1N.t4 VSS.t41 VSS.t40 nfet_03v3 ad=0.915p pd=4.22u as=0.915p ps=4.22u w=1.5u l=0.28u
X10 a_70505_33852.t1 a_73597_33018.t2 VDD.t16 VDD.t15 pfet_03v3 ad=0.728p pd=3.54u as=0.728p ps=3.54u w=1.12u l=0.28u
X11 VTUNE.t0 O2N.t1 cap_nmos_03v3 c_width=1u c_length=1u
X12 O2N.t0 O4N.t4 VDD_VCO.t9 VDD_VCO.t8 pfet_03v3 ad=1.95p pd=7.3u as=1.95p ps=7.3u w=3u l=0.28u
X13 O4P.t3 O3P.t4 VSS.t49 VSS.t48 nfet_03v3 ad=0.915p pd=4.22u as=0.915p ps=4.22u w=1.5u l=0.28u
X14 a_72017_31124.t0 CORE_CLK.t2 VSS.t14 VSS.t13 nfet_03v3 ad=0.1456p pd=1.08u as=0.3416p ps=2.34u w=0.56u l=0.28u
X15 a_69119_31958.t0 a_69087_33798.t5 a_69317_32762.t0 VDD.t14 pfet_03v3 ad=0.728p pd=3.54u as=0.728p ps=3.54u w=1.12u l=0.28u
X16 a_69257_32706.t0 a_69985_32940.t2 VDD.t24 VDD.t23 pfet_03v3 ad=0.2432p pd=2.06u as=0.2432p ps=2.06u w=0.36u l=0.36u
X17 a_76968_33670.t2 MIM_TOP.t2 VSS.t87 VSS.t86 nfet_03v3 ad=0.61p pd=3.22u as=0.61p ps=3.22u w=1u l=0.28u
X18 a_70565_33748.t1 a_70505_33684.t8 a_70565_33580.t1 VSS.t10 nfet_03v3 ad=93.59999f pd=0.88u as=93.59999f ps=0.88u w=0.36u l=0.32u
X19 a_69087_33798.t0 CORE_CLK.t4 a_72617_31132.t0 VSS.t12 nfet_03v3 ad=0.3416p pd=2.34u as=0.1456p ps=1.08u w=0.56u l=0.28u
X20 VDD.t11 CORE_CLK.t7 a_71955_31748.t0 VDD.t0 pfet_03v3 ad=0.728p pd=3.54u as=0.728p ps=3.54u w=1.12u l=0.28u
X21 a_76557_32392.t0 DOUBLER_K.t4 VSS.t73 ppolyf_u r_width=0.8u r_length=6.705u
X22 a_71607_33716.t0 a_70505_33852.t6 PRESCALED.t1 VSS.t84 nfet_03v3 ad=0.1456p pd=1.08u as=0.3416p ps=2.34u w=0.56u l=0.28u
X23 a_70505_33684.t1 a_73225_31738.t3 a_75155_31132.t0 VSS.t44 nfet_03v3 ad=0.3416p pd=2.34u as=0.1456p ps=1.08u w=0.56u l=0.28u
X24 VDD.t37 a_73225_31738.t5 a_74493_31748.t1 VDD.t36 pfet_03v3 ad=0.728p pd=3.54u as=0.728p ps=3.54u w=1.12u l=0.28u
X25 a_74555_31124.t0 a_73225_31738.t2 VSS.t81 VSS.t80 nfet_03v3 ad=0.1456p pd=1.08u as=0.3416p ps=2.34u w=0.56u l=0.28u
X26 VTUNE.t4 O3N.t2 cap_nmos_03v3 c_width=1u c_length=1u
X27 a_72207_33724.t1 a_72147_33668.t2 a_71397_33018.t1 VSS.t28 nfet_03v3 ad=0.1456p pd=1.08u as=0.3416p ps=2.34u w=0.56u l=0.28u
X28 O3N.t3 O3P.t5 VSS.t47 VSS.t46 nfet_03v3 ad=0.4697p pd=2.76u as=0.4697p ps=2.76u w=0.77u l=0.28u
X29 O1N.t3 O1P.t6 VSS.t33 VSS.t32 nfet_03v3 ad=0.4697p pd=2.76u as=0.4697p ps=2.76u w=0.77u l=0.28u
X30 PRESCALED.t0 a_71397_33018.t2 VDD.t5 VDD.t4 pfet_03v3 ad=0.728p pd=3.54u as=0.728p ps=3.54u w=1.12u l=0.28u
X31 VDD.t22 a_80362_35700.t3 a_79278_35710.t1 VDD.t21 pfet_03v3 ad=1.3p pd=5.3u as=1.3p ps=5.3u w=2u l=0.28u
X32 a_73597_33018.t1 a_70505_33684.t4 VDD.t39 VDD.t38 pfet_03v3 ad=0.728p pd=3.54u as=0.728p ps=3.54u w=1.12u l=0.28u
X33 VDD_VCO.t5 O1N.t6 O3P.t3 VDD_VCO.t4 pfet_03v3 ad=1.95p pd=7.3u as=1.95p ps=7.3u w=3u l=0.28u
X34 a_70517_31292.t0 CORE_CLK.t5 a_70517_31132.t0 VSS.t11 nfet_03v3 ad=0.3416p pd=2.34u as=0.1456p ps=1.08u w=0.56u l=0.28u
D0 O1N.t7 DOUBLER_K sc_diode pj=3.24u area=0.62p
X35 a_70565_33580.t0 CORE_CLK.t11 a_70565_33412.t0 VSS.t10 nfet_03v3 ad=93.59999f pd=0.88u as=93.59999f ps=0.88u w=0.36u l=0.32u
X36 O2N.t3 O2P.t4 VSS.t76 VSS.t75 nfet_03v3 ad=0.4697p pd=2.76u as=0.4697p ps=2.76u w=0.77u l=0.28u
X37 a_76557_34612.t0 a_78030_34352.t0 VSS.t25 ppolyf_u r_width=0.8u r_length=6.705u
X38 VSS.t37 a_69257_32706.t3 a_69119_31958.t2 VSS.t36 nfet_03v3 ad=0.3416p pd=2.34u as=0.3416p ps=2.34u w=0.56u l=0.28u
X39 a_76557_31872.t1 a_78030_32132.t1 VSS.t85 ppolyf_u r_width=0.8u r_length=6.705u
X40 O4P.t1 O4N.t5 VSS.t53 VSS.t52 nfet_03v3 ad=0.4697p pd=2.76u as=0.4697p ps=2.76u w=0.77u l=0.28u
X41 a_69985_32940.t1 a_69087_33798.t4 a_70530_32714.t1 VDD.t53 pfet_03v3 ad=0.468p pd=2.74u as=0.1872p ps=1.24u w=0.72u l=0.32u
X43 VDD_VCO.t13 O4P.t5 O2P.t2 VDD_VCO.t12 pfet_03v3 ad=1.95p pd=7.3u as=1.95p ps=7.3u w=3u l=0.28u
X44 VTUNE.t6 O1N.t0 cap_nmos_03v3 c_width=1u c_length=1u
X45 a_69255_31678.t1 a_69119_31958.t3 VSS.t90 VSS.t89 nfet_03v3 ad=0.3416p pd=2.34u as=0.3416p ps=2.34u w=0.56u l=0.28u
X46 VSS.t62 PRESCALED.t3 a_72147_33668.t0 VSS.t61 nfet_03v3 ad=0.3416p pd=2.34u as=0.3416p ps=2.34u w=0.56u l=0.28u
X47 VTUNE.t2 O4N.t0 cap_nmos_03v3 c_width=1u c_length=1u
X48 VDD.t35 a_79278_35710.t3 CORE_CLK.t1 VDD.t34 pfet_03v3 ad=2.6p pd=9.3u as=2.6p ps=9.3u w=4u l=0.28u
X49 MIM_TOP.t1 DOUBLER_K.t5 cap_mim_2f0_m5m6_noshield c_width=5u c_length=5u
X50 VDD.t1 a_71955_31748.t3 a_69087_33798.t1 VDD.t0 pfet_03v3 ad=0.728p pd=3.54u as=0.728p ps=3.54u w=1.12u l=0.28u
X51 VDD.t41 a_69119_31958.t4 a_69255_31864.t1 VDD.t40 pfet_03v3 ad=0.728p pd=3.54u as=0.2912p ps=1.64u w=1.12u l=0.28u
X52 VDD.t18 a_74493_31748.t3 a_70505_33684.t0 VDD.t17 pfet_03v3 ad=0.728p pd=3.54u as=0.728p ps=3.54u w=1.12u l=0.28u
X53 a_69317_32762.t1 a_69257_32706.t2 VDD.t43 VDD.t42 pfet_03v3 ad=0.728p pd=3.54u as=0.728p ps=3.54u w=1.12u l=0.28u
X54 a_70565_34084.t1 PRESCALED.t4 a_70565_33916.t0 VSS.t29 nfet_03v3 ad=93.59999f pd=0.88u as=93.59999f ps=0.88u w=0.36u l=0.32u
X55 VSS.t9 CORE_CLK.t12 a_70045_33584.t0 VSS.t8 nfet_03v3 ad=0.228p pd=1.98u as=93.59999f ps=0.88u w=0.36u l=0.36u
X56 O1N.t1 O3N.t5 VDD_VCO.t11 VDD_VCO.t10 pfet_03v3 ad=1.95p pd=7.3u as=1.95p ps=7.3u w=3u l=0.28u
X57 a_69855_31748.t1 a_69255_31678.t2 a_69917_31124.t1 VSS.t15 nfet_03v3 ad=0.3416p pd=2.34u as=0.1456p ps=1.08u w=0.56u l=0.28u
X58 a_71397_33018.t0 a_70505_33852.t3 VDD.t50 VDD.t49 pfet_03v3 ad=0.728p pd=3.54u as=0.728p ps=3.54u w=1.12u l=0.28u
D1 O1P.t7 DOUBLER_K sc_diode pj=3.24u area=0.62p
X60 a_72617_31132.t1 a_71955_31748.t2 VSS.t72 VSS.t12 nfet_03v3 ad=0.1456p pd=1.08u as=0.3416p ps=2.34u w=0.56u l=0.28u
X61 VDD.t25 a_69855_31748.t3 a_70517_31292.t1 VDD.t8 pfet_03v3 ad=0.728p pd=3.54u as=0.728p ps=3.54u w=1.12u l=0.28u
X62 VSS.t83 a_73597_33018.t3 a_73807_33716.t1 VSS.t65 nfet_03v3 ad=0.3416p pd=2.34u as=0.1456p ps=1.08u w=0.56u l=0.28u
X63 VSS.t27 a_69087_33798.t7 a_69119_31958.t1 VSS.t26 nfet_03v3 ad=0.3416p pd=2.34u as=0.3416p ps=2.34u w=0.56u l=0.28u
X64 a_75155_31132.t1 a_74493_31748.t2 VSS.t45 VSS.t44 nfet_03v3 ad=0.1456p pd=1.08u as=0.3416p ps=2.34u w=0.56u l=0.28u
X65 VSS.t55 O3N.t6 O3P.t0 VSS.t54 nfet_03v3 ad=0.4697p pd=2.76u as=0.4697p ps=2.76u w=0.77u l=0.28u
X66 a_69255_31864.t0 CORE_CLK.t8 a_69255_31678.t0 VDD.t10 pfet_03v3 ad=0.2912p pd=1.64u as=0.728p ps=3.54u w=1.12u l=0.28u
X67 O4P.t0 O2N.t4 VDD_VCO.t1 VDD_VCO.t0 pfet_03v3 ad=1.95p pd=7.3u as=1.95p ps=7.3u w=3u l=0.28u
X68 VSS.t39 O1N.t5 O1P.t1 VSS.t38 nfet_03v3 ad=0.4697p pd=2.76u as=0.4697p ps=2.76u w=0.77u l=0.28u
X69 a_74347_33668.t0 a_70505_33684.t5 a_74957_32984.t0 VDD.t13 pfet_03v3 ad=0.728p pd=3.54u as=0.2912p ps=1.64u w=1.12u l=0.28u
X70 a_80630_35072.t2 TAIL_BIAS.t0 VSS.t64 VSS.t63 nfet_03v3 ad=0.61p pd=3.22u as=0.61p ps=3.22u w=1u l=0.28u
X71 VSS.t67 a_70505_33684.t7 a_74407_33724.t1 VSS.t66 nfet_03v3 ad=0.3416p pd=2.34u as=0.1456p ps=1.08u w=0.56u l=0.28u
X72 VSS.t3 O2N.t5 O2P.t0 VSS.t2 nfet_03v3 ad=0.4697p pd=2.76u as=0.4697p ps=2.76u w=0.77u l=0.28u
X73 VTUNE.t3 O2P.t1 cap_nmos_03v3 c_width=1u c_length=1u
X74 a_71355_31678.t1 a_70517_31292.t2 VSS.t20 VSS.t19 nfet_03v3 ad=0.3416p pd=2.34u as=0.3416p ps=2.34u w=0.56u l=0.28u
X75 VSS.t71 O4P.t4 O4N.t2 VSS.t70 nfet_03v3 ad=0.4697p pd=2.76u as=0.4697p ps=2.76u w=0.77u l=0.28u
X76 a_79278_35710.t0 O1P.t8 a_80630_35072.t0 VSS.t31 nfet_03v3 ad=0.61p pd=3.22u as=0.61p ps=3.22u w=1u l=0.28u
X77 a_70565_33412.t1 a_69087_33798.t6 a_69985_32940.t0 VSS.t74 nfet_03v3 ad=93.59999f pd=0.88u as=0.228p ps=1.98u w=0.36u l=0.32u
X78 a_70517_31132.t1 a_69855_31748.t2 VSS.t79 VSS.t11 nfet_03v3 ad=0.1456p pd=1.08u as=0.3416p ps=2.34u w=0.56u l=0.28u
X79 a_71955_31748.t1 a_71355_31678.t2 a_72017_31124.t1 VSS.t13 nfet_03v3 ad=0.3416p pd=2.34u as=0.1456p ps=1.08u w=0.56u l=0.28u
X80 a_74957_32984.t1 a_70505_33852.t2 VDD.t48 VDD.t47 pfet_03v3 ad=0.2912p pd=1.64u as=0.728p ps=3.54u w=1.12u l=0.28u
X81 VSS.t78 O2P.t6 O3P.t2 VSS.t77 nfet_03v3 ad=0.915p pd=4.22u as=0.915p ps=4.22u w=1.5u l=0.28u
X82 VDD.t29 a_70517_31292.t3 a_71355_31864.t1 VDD.t28 pfet_03v3 ad=0.728p pd=3.54u as=0.2912p ps=1.64u w=1.12u l=0.28u
X83 a_76557_34092.t0 MIM_TOP.t0 VSS.t25 ppolyf_u r_width=0.8u r_length=6.705u
X84 VSS.t51 O4N.t6 O1P.t3 VSS.t50 nfet_03v3 ad=0.915p pd=4.22u as=0.915p ps=4.22u w=1.5u l=0.28u
X85 VSS.t35 O1P.t4 O2P.t3 VSS.t34 nfet_03v3 ad=0.915p pd=4.22u as=0.915p ps=4.22u w=1.5u l=0.28u
X86 CORE_CLK.t0 a_79278_35710.t2 VSS.t24 VSS.t23 nfet_03v3 ad=1.22p pd=5.22u as=1.22p ps=5.22u w=2u l=0.28u
X87 VSS.t88 a_71397_33018.t3 a_71607_33716.t1 VSS.t84 nfet_03v3 ad=0.3416p pd=2.34u as=0.1456p ps=1.08u w=0.56u l=0.28u
X88 a_70565_33916.t1 a_70505_33852.t8 a_70565_33748.t0 VSS.t10 nfet_03v3 ad=93.59999f pd=0.88u as=93.59999f ps=0.88u w=0.36u l=0.32u
X89 a_73893_31678.t0 a_70505_33684.t2 VSS.t43 VSS.t42 nfet_03v3 ad=0.3416p pd=2.34u as=0.3416p ps=2.34u w=0.56u l=0.28u
X90 VDD.t52 MIM_TOP.t3 a_76968_33670.t1 VDD.t51 pfet_03v3 ad=1.3p pd=5.3u as=1.3p ps=5.3u w=2u l=0.28u
X91 VSS.t57 O3N.t4 O4N.t1 VSS.t56 nfet_03v3 ad=0.915p pd=4.22u as=0.915p ps=4.22u w=1.5u l=0.28u
X92 VTUNE.t5 O3P.t1 cap_nmos_03v3 c_width=1u c_length=1u
X93 VDD.t33 a_69087_33798.t3 a_73225_31738.t1 VDD.t32 pfet_03v3 ad=0.728p pd=3.54u as=0.728p ps=3.54u w=1.12u l=0.28u
X94 VDD_VCO.t7 O3P.t6 O1P.t2 VDD_VCO.t6 pfet_03v3 ad=1.95p pd=7.3u as=1.95p ps=7.3u w=3u l=0.28u
X96 a_72147_33668.t1 a_70505_33852.t4 a_72757_32984.t1 VDD.t46 pfet_03v3 ad=0.728p pd=3.54u as=0.2912p ps=1.64u w=1.12u l=0.28u
X97 a_74493_31748.t0 a_73893_31678.t2 a_74555_31124.t1 VSS.t80 nfet_03v3 ad=0.3416p pd=2.34u as=0.1456p ps=1.08u w=0.56u l=0.28u
X98 VSS.t58 a_70505_33852.t7 a_72207_33724.t0 VSS.t28 nfet_03v3 ad=0.3416p pd=2.34u as=0.1456p ps=1.08u w=0.56u l=0.28u
X99 VDD.t27 a_70505_33684.t3 a_73893_31864.t0 VDD.t26 pfet_03v3 ad=0.728p pd=3.54u as=0.2912p ps=1.64u w=1.12u l=0.28u
X100 a_73225_31738.t0 a_69087_33798.t2 VSS.t22 VSS.t21 nfet_03v3 ad=0.3416p pd=2.34u as=0.3416p ps=2.34u w=0.56u l=0.28u
X101 a_71355_31864.t0 CORE_CLK.t6 a_71355_31678.t0 VDD.t12 pfet_03v3 ad=0.2912p pd=1.64u as=0.728p ps=3.54u w=1.12u l=0.28u
X102 a_76557_34612.t1 a_76968_33670.t0 VSS.t25 ppolyf_u r_width=0.8u r_length=6.705u
X103 VDD_VCO.t15 O2P.t5 O4N.t3 VDD_VCO.t14 pfet_03v3 ad=1.95p pd=7.3u as=1.95p ps=7.3u w=3u l=0.28u
X104 VDD.t9 CORE_CLK.t9 a_69855_31748.t0 VDD.t8 pfet_03v3 ad=0.728p pd=3.54u as=0.728p ps=3.54u w=1.12u l=0.28u
X105 a_76557_32392.t1 a_78030_32132.t0 VSS.t82 ppolyf_u r_width=0.8u r_length=6.705u
X106 VTUNE.t7 O1P.t0 cap_nmos_03v3 c_width=1u c_length=1u
X107 a_70045_33584.t1 a_69985_32940.t3 a_69257_32706.t1 VSS.t8 nfet_03v3 ad=93.59999f pd=0.88u as=0.228p ps=1.98u w=0.36u l=0.36u
X108 VTUNE.t1 O4P.t2 cap_nmos_03v3 c_width=1u c_length=1u
X109 a_69917_31124.t0 CORE_CLK.t3 VSS.t16 VSS.t15 nfet_03v3 ad=0.1456p pd=1.08u as=0.3416p ps=2.34u w=0.56u l=0.28u
X110 a_72757_32984.t0 PRESCALED.t2 VDD.t31 VDD.t30 pfet_03v3 ad=0.2912p pd=1.64u as=0.728p ps=3.54u w=1.12u l=0.28u
X111 a_73807_33716.t0 a_70505_33684.t6 a_70505_33852.t0 VSS.t65 nfet_03v3 ad=0.1456p pd=1.08u as=0.3416p ps=2.34u w=0.56u l=0.28u
X112 a_80362_35700.t0 O1N.t8 a_80630_35072.t1 VSS.t31 nfet_03v3 ad=0.61p pd=3.22u as=0.61p ps=3.22u w=1u l=0.28u
X113 O3N.t1 O2N.t6 VSS.t1 VSS.t0 nfet_03v3 ad=0.915p pd=4.22u as=0.915p ps=4.22u w=1.5u l=0.28u
X115 a_76557_31872.t0 VSS.t18 VSS.t17 ppolyf_u r_width=0.8u r_length=6.705u
R0 O2N.n0 O2N.t4 75.1037
R1 O2N.n0 O2N.t6 45.8816
R2 O2N.n1 O2N.t5 29.5094
R3 O2N.n2 O2N.t3 9.89919
R4 O2N.n3 O2N.t1 5.83651
R5 O2N O2N.t2 4.8305
R6 O2N.n1 O2N.n0 4.5005
R7 O2N.n3 O2N.t0 2.34277
R8 O2N.n2 O2N.n1 1.59898
R9 O2N.n4 O2N.n3 0.68137
R10 O2N O2N.n4 0.360243
R11 O2N.n4 O2N.n2 0.0591957
R12 O4P.n0 O4P.t5 63.0791
R13 O4P.n0 O4P.t6 45.3692
R14 O4P.n1 O4P.t4 29.5094
R15 O4P O4P.t1 9.60046
R16 O4P.n2 O4P.t2 5.85967
R17 O4P.n1 O4P.n0 5.40565
R18 O4P.n3 O4P.t3 5.20589
R19 O4P.n2 O4P.t0 2.37525
R20 O4P.n4 O4P.n1 1.60289
R21 O4P.n3 O4P.n2 0.554196
R22 O4P O4P.n4 0.283578
R23 O4P.n4 O4P.n3 0.0591957
R24 O3N.n2 O3N.t5 63.0791
R25 O3N.n2 O3N.t4 56.1802
R26 O3N.n0 O3N.t6 31.1079
R27 O3N.n3 O3N.n2 14.2002
R28 O3N.n0 O3N.t3 9.89919
R29 O3N.n1 O3N.t2 5.51194
R30 O3N O3N.t1 4.8305
R31 O3N.n1 O3N.t0 2.0205
R32 O3N.n4 O3N.n3 0.923978
R33 O3N O3N.n4 0.360243
R34 O3N.n3 O3N.n1 0.0838684
R35 O3N.n4 O3N.n0 0.0591957
R36 O2P.n4 O2P.t5 67.5834
R37 O2P O2P.t6 43.5255
R38 O2P.n0 O2P.t4 31.1146
R39 O2P.n4 O2P.n3 10.1243
R40 O2P.n0 O2P.t0 9.88354
R41 O2P.n2 O2P.t1 5.60495
R42 O2P O2P.n4 7.0947
R43 O2P.n1 O2P.t3 5.20589
R44 O2P.n3 O2P.t2 2.07971
R45 O2P.n2 O2P.n1 0.612891
R46 O2P.n3 O2P.n2 0.230587
R47 O2P.n1 O2P.n0 0.0591957
R48 O4N.n0 O4N.t4 66.559
R49 O4N.n0 O4N.t6 46.765
R50 O4N.n2 O4N.t5 29.5705
R51 O4N.n3 O4N.t2 9.89919
R52 O4N.n2 O4N.t0 5.31523
R53 O4N O4N.t1 4.8305
R54 O4N.n1 O4N.n0 4.73971
R55 O4N.n1 O4N.t3 2.0205
R56 O4N.n3 O4N.n2 1.54986
R57 O4N.n4 O4N.n1 1.01315
R58 O4N O4N.n4 0.360243
R59 O4N.n4 O4N.n3 0.0591957
R60 O3P.n4 O3P.t6 68.7094
R61 O3P O3P.t4 43.5255
R62 O3P.n0 O3P.t5 31.1146
R63 O3P O3P.n4 20.6216
R64 O3P.n0 O3P.t0 9.88354
R65 O3P.n4 O3P.n3 9.0005
R66 O3P.n2 O3P.t1 6.21719
R67 O3P.n1 O3P.t2 5.20589
R68 O3P.n3 O3P.t3 2.08208
R69 O3P.n2 O3P.n1 0.616804
R70 O3P.n3 O3P.n2 0.224424
R71 O3P.n1 O3P.n0 0.0591957
R72 RF_OUT RF_OUT.n0 22.5005
R73 RF_OUT.n0 RF_OUT.t0 8.8205
R74 RF_OUT.n0 RF_OUT.t1 3.78636
R75 PRESCALED PRESCALED.n2 51.6332
R76 PRESCALED.n0 PRESCALED.t2 38.5719
R77 PRESCALED.n0 PRESCALED.t3 32.593
R78 PRESCALED.n1 PRESCALED.t4 25.1851
R79 PRESCALED.n1 PRESCALED.t1 10.8005
R80 PRESCALED.n2 PRESCALED.n1 10.5912
R81 PRESCALED.n1 PRESCALED.t0 6.00776
R82 PRESCALED.n2 PRESCALED.n0 5.099
R83 MIM_TOP.n0 MIM_TOP.t3 45.5434
R84 MIM_TOP MIM_TOP.t2 32.5076
R85 MIM_TOP.n1 MIM_TOP.t1 23.055
R86 MIM_TOP.n0 MIM_TOP.t0 12.2404
R87 MIM_TOP.n1 MIM_TOP.n0 0.497457
R88 MIM_TOP MIM_TOP.n1 0.250935
R89 MC MC.t0 74.1077
R90 TAIL_BIAS TAIL_BIAS.t0 55.0076
R91 O1N.n0 O1N.t6 66.2998
R92 O1N.n0 O1N.t4 57.5208
R93 O1N.n5 O1N.t8 50.5431
R94 O1N.n3 O1N.t5 31.1146
R95 O1N.n4 O1N.t7 14.3684
R96 O1N.n6 O1N.n5 14.0546
R97 O1N.n6 O1N.t3 9.57323
R98 O1N.n4 O1N.t0 20.352
R99 O1N.n2 O1N.t2 5.20589
R100 O1N.n1 O1N.n0 4.5005
R101 O1N.n1 O1N.t1 2.08918
R102 O1N.n2 O1N.n1 0.923978
R103 O1N.n5 O1N.n4 0.550143
R104 O1N O1N.n3 0.281799
R105 O1N.n3 O1N.n2 0.0591957
R106 O1N O1N.n6 0.026375
R107 VTUNE.n0 VTUNE.t5 32.6395
R108 VTUNE.n3 VTUNE.t2 32.212
R109 VTUNE.n4 VTUNE.t6 31.7395
R110 VTUNE.n3 VTUNE.t1 31.7395
R111 VTUNE.n0 VTUNE.t4 31.7395
R112 VTUNE.n1 VTUNE.t3 31.7395
R113 VTUNE.n2 VTUNE.t0 31.7395
R114 VTUNE VTUNE.n5 22.7005
R115 VTUNE.n5 VTUNE.n4 18.518
R116 VTUNE.n5 VTUNE.t7 13.7345
R117 VTUNE.n4 VTUNE.n3 7.55825
R118 VTUNE.n3 VTUNE.n2 4.23725
R119 VTUNE.n1 VTUNE.n0 0.9005
R120 VTUNE.n2 VTUNE.n1 0.9005
R121 O1P.n1 O1P.t5 77.3804
R122 O1P.n1 O1P.t4 48.5871
R123 O1P.n2 O1P.t8 45.2041
R124 O1P.n4 O1P.t6 29.5094
R125 O1P.n2 O1P.t7 10.5643
R126 O1P.n5 O1P.t1 9.89919
R127 O1P.n0 O1P.t0 16.9132
R128 O1P.n3 O1P.n1 7.74927
R129 O1P.n3 O1P.n2 4.93121
R130 O1P O1P.t3 4.8305
R131 O1P.n4 O1P.n3 4.5894
R132 O1P.n0 O1P.t2 2.0205
R133 O1P.n5 O1P.n4 1.59898
R134 O1P.n6 O1P.n0 1.01315
R135 O1P O1P.n6 0.360243
R136 O1P.n6 O1P.n5 0.0591957
R137 CORE_CLK CORE_CLK.n8 43.3858
R138 CORE_CLK.n3 CORE_CLK.t9 34.9895
R139 CORE_CLK.n1 CORE_CLK.t7 34.9895
R140 CORE_CLK.n0 CORE_CLK.t6 34.3028
R141 CORE_CLK.n2 CORE_CLK.t8 34.3028
R142 CORE_CLK.n0 CORE_CLK.t2 30.5324
R143 CORE_CLK.n2 CORE_CLK.t3 30.5324
R144 CORE_CLK.n1 CORE_CLK.t4 30.1998
R145 CORE_CLK.n4 CORE_CLK.t5 29.3232
R146 CORE_CLK.n6 CORE_CLK.t10 27.3622
R147 CORE_CLK CORE_CLK.t12 25.8838
R148 CORE_CLK.n7 CORE_CLK.t11 22.6005
R149 CORE_CLK CORE_CLK.n7 5.47531
R150 CORE_CLK.n8 CORE_CLK.t0 3.46589
R151 CORE_CLK.n3 CORE_CLK.n2 2.47746
R152 CORE_CLK.n7 CORE_CLK.n6 2.33267
R153 CORE_CLK.n8 CORE_CLK.t1 2.24562
R154 CORE_CLK.n5 CORE_CLK.n4 1.79659
R155 CORE_CLK.n5 CORE_CLK.n1 1.43659
R156 CORE_CLK.n5 CORE_CLK.n0 1.04137
R157 CORE_CLK.n4 CORE_CLK.n3 0.877022
R158 CORE_CLK.n6 CORE_CLK.n5 0.434848
R159 VDD_VCO.n11 VDD_VCO.t8 1036.59
R160 VDD_VCO.n11 VDD_VCO.t0 1036.59
R161 VDD_VCO.n0 VDD_VCO.t4 1036.59
R162 VDD_VCO.n0 VDD_VCO.t6 1036.59
R163 VDD_VCO.n6 VDD_VCO.t10 275.774
R164 VDD_VCO.n6 VDD_VCO.t14 275.774
R165 VDD_VCO.n5 VDD_VCO.t2 275.774
R166 VDD_VCO.n5 VDD_VCO.t12 275.774
R167 VDD_VCO.n7 VDD_VCO.n5 272.728
R168 VDD_VCO.n7 VDD_VCO.n6 231.405
R169 VDD_VCO.n8 VDD_VCO.n7 26.1095
R170 VDD_VCO.n12 VDD_VCO.n11 17.1005
R171 VDD_VCO.n1 VDD_VCO.n0 17.1005
R172 VDD_VCO.n14 VDD_VCO.n13 10.6058
R173 VDD_VCO VDD_VCO.n14 9.0005
R174 VDD_VCO.n12 VDD_VCO.t9 7.09425
R175 VDD_VCO.n1 VDD_VCO.t7 7.07775
R176 VDD_VCO.n3 VDD_VCO.t13 6.72214
R177 VDD_VCO.n9 VDD_VCO.t11 6.70061
R178 VDD_VCO.n2 VDD_VCO.t5 6.59132
R179 VDD_VCO.n9 VDD_VCO.t15 6.56561
R180 VDD_VCO.n3 VDD_VCO.t3 6.54407
R181 VDD_VCO.n13 VDD_VCO.t1 6.5205
R182 VDD_VCO.n4 VDD_VCO.n2 6.46218
R183 VDD_VCO.n8 VDD_VCO.n4 5.108
R184 VDD_VCO.n10 VDD_VCO.n8 5.063
R185 VDD_VCO.n14 VDD_VCO.n10 4.91112
R186 VDD_VCO.n4 VDD_VCO.n3 4.5005
R187 VDD_VCO.n10 VDD_VCO.n9 4.5005
R188 VDD_VCO.n13 VDD_VCO.n12 0.572
R189 VDD_VCO.n2 VDD_VCO.n1 0.450758
R190 VDD.n2 VDD.t34 1778.9
R191 VDD.t21 VDD.t19 1379.31
R192 VDD.n7 VDD.t44 821.139
R193 VDD.n6 VDD.t2 821.139
R194 VDD.n7 VDD.t51 804.879
R195 VDD.t44 VDD.n6 804.879
R196 VDD.n34 VDD.t4 415
R197 VDD.n34 VDD.t49 415
R198 VDD.n26 VDD.t38 415
R199 VDD.n49 VDD.t15 415
R200 VDD.t30 VDD.t46 400
R201 VDD.t47 VDD.t13 400
R202 VDD.n3 VDD.n2 324.796
R203 VDD.n21 VDD.t36 312.122
R204 VDD.n52 VDD.n26 312.122
R205 VDD.n27 VDD.t6 258.654
R206 VDD.n49 VDD.n48 253.03
R207 VDD.t23 VDD.t14 224.839
R208 VDD.n41 VDD.n40 198.537
R209 VDD.n34 VDD.t30 190
R210 VDD.n20 VDD.t47 190
R211 VDD.n2 VDD.t21 168.357
R212 VDD.n20 VDD.n19 156.061
R213 VDD.t26 VDD.n51 156.061
R214 VDD.n36 VDD.n34 108.674
R215 VDD.n48 VDD.t28 101.359
R216 VDD.n25 VDD.n17 96.9702
R217 VDD.n48 VDD.n33 96.8074
R218 VDD.t53 VDD.t23 82.2996
R219 VDD.t42 VDD.t53 75.768
R220 VDD.n48 VDD.t32 69.2421
R221 VDD.n48 VDD.n32 58.7856
R222 VDD.n48 VDD.n47 47.0224
R223 VDD.t28 VDD.t0 47.0224
R224 VDD.t8 VDD.t10 45.7222
R225 VDD.n33 VDD.t8 44.9112
R226 VDD.n21 VDD.n20 39.3944
R227 VDD.n52 VDD.t26 39.3944
R228 VDD.t0 VDD.t12 36.5731
R229 VDD.t6 VDD.t42 33.9652
R230 VDD.n10 VDD.n3 30.7609
R231 VDD.n10 VDD.n9 29.9225
R232 VDD.n59 VDD.t24 26.9179
R233 VDD.n8 VDD.n7 26.1005
R234 VDD.n6 VDD.n5 26.1005
R235 VDD.n58 VDD.t7 22.7981
R236 VDD.n19 VDD.t17 22.7278
R237 VDD.n51 VDD.n49 22.7278
R238 VDD.n60 VDD.t43 18.7805
R239 VDD.n5 VDD.t3 17.117
R240 VDD.n4 VDD.t45 16.7038
R241 VDD.n62 VDD.n61 15.9933
R242 VDD.n9 VDD.n8 13.9055
R243 VDD.n29 VDD.n27 12.6005
R244 VDD.n43 VDD.n41 12.6005
R245 VDD.n40 VDD.n39 12.6005
R246 VDD.n17 VDD.n16 12.6005
R247 VDD.n25 VDD.n24 12.6005
R248 VDD VDD.n62 10.3447
R249 VDD.n33 VDD.t40 9.47894
R250 VDD.n55 VDD.n54 9.26037
R251 VDD.n55 VDD.n14 9.1223
R252 VDD.n56 VDD.n13 9.1223
R253 VDD.n61 VDD.n11 9.11468
R254 VDD.n57 VDD.n12 9.11468
R255 VDD.n45 VDD.t33 6.03129
R256 VDD.n24 VDD.t39 5.4265
R257 VDD.n16 VDD.t37 5.4265
R258 VDD.n29 VDD.t9 5.4265
R259 VDD.n39 VDD.t50 5.4265
R260 VDD.n43 VDD.t11 5.4265
R261 VDD.n50 VDD.t16 5.422
R262 VDD.n31 VDD.t25 5.422
R263 VDD.n35 VDD.t5 5.422
R264 VDD.n46 VDD.t1 5.422
R265 VDD.n18 VDD.t18 5.422
R266 VDD.n22 VDD.t48 5.3545
R267 VDD.n53 VDD.t27 5.3545
R268 VDD.n28 VDD.t41 5.3545
R269 VDD.n37 VDD.t31 5.3545
R270 VDD.n42 VDD.t29 5.3545
R271 VDD.n24 VDD.n23 4.5005
R272 VDD.n30 VDD.n29 4.5005
R273 VDD.n39 VDD.n38 4.5005
R274 VDD.n44 VDD.n43 4.5005
R275 VDD.n16 VDD.n15 4.5005
R276 VDD.n0 VDD.t20 4.31802
R277 VDD.n32 VDD.n27 3.91951
R278 VDD.n0 VDD.t22 3.20383
R279 VDD.n9 VDD.t52 3.20383
R280 VDD.n32 VDD.n31 3.1505
R281 VDD.n32 VDD.n28 3.1505
R282 VDD.n47 VDD.n46 3.1505
R283 VDD.n47 VDD.n42 3.1505
R284 VDD.n37 VDD.n36 3.1505
R285 VDD.n36 VDD.n35 3.1505
R286 VDD.n53 VDD.n52 3.1505
R287 VDD.n22 VDD.n21 3.1505
R288 VDD.n51 VDD.n50 3.1505
R289 VDD.n19 VDD.n18 3.1505
R290 VDD.n40 VDD.n36 3.1353
R291 VDD.n47 VDD.n41 3.1353
R292 VDD.t36 VDD.n17 3.0308
R293 VDD.n26 VDD.n25 3.0308
R294 VDD.n1 VDD.t35 2.88808
R295 VDD.n18 VDD.n15 2.37486
R296 VDD.n31 VDD.n30 2.37386
R297 VDD.n45 VDD.n44 2.36968
R298 VDD.n62 VDD.n10 2.17075
R299 VDD.n23 VDD.n22 2.16537
R300 VDD.n38 VDD.n37 2.16537
R301 VDD.n54 VDD.n53 1.50205
R302 VDD.n28 VDD.n11 1.50042
R303 VDD.n42 VDD.n12 1.50042
R304 VDD.n50 VDD.n14 1.49976
R305 VDD.n35 VDD.n13 1.49976
R306 VDD.n56 VDD.n55 1.238
R307 VDD.n23 VDD.n14 0.874819
R308 VDD.n38 VDD.n13 0.874819
R309 VDD.n30 VDD.n11 0.666015
R310 VDD.n44 VDD.n12 0.666015
R311 VDD.n54 VDD.n15 0.664819
R312 VDD.n58 VDD.n57 0.516313
R313 VDD.n8 VDD.n4 0.413682
R314 VDD.n5 VDD.n4 0.4055
R315 VDD.n60 VDD.n59 0.36725
R316 VDD.n3 VDD.n1 0.354717
R317 VDD.n59 VDD.n58 0.293563
R318 VDD.n1 VDD.n0 0.0952368
R319 VDD.n57 VDD.n56 0.0455
R320 VDD.n61 VDD.n60 0.006125
R321 VDD.n46 VDD.n45 0.00568217
R322 DOUBLER_K.n0 DOUBLER_K.t4 18.1653
R323 DOUBLER_K.n0 DOUBLER_K.t5 13.7268
R324 DOUBLER_K DOUBLER_K.n0 4.5005
R325 VSS.n103 VSS.t26 232163
R326 VSS.n33 VSS.n32 157950
R327 VSS.n32 VSS.t8 146984
R328 VSS.n59 VSS.n38 125061
R329 VSS.n36 VSS.n34 97825
R330 VSS.n32 VSS.t74 73804.3
R331 VSS.n73 VSS.n33 55747.6
R332 VSS.n83 VSS.n82 50135.5
R333 VSS.n103 VSS.t89 33737
R334 VSS.n84 VSS.n83 17201.4
R335 VSS.t84 VSS.t10 8026.74
R336 VSS.n36 VSS.n35 7854.17
R337 VSS.n32 VSS.t65 7391.86
R338 VSS.n34 VSS.n12 5644.74
R339 VSS.n75 VSS.n74 4951.97
R340 VSS.t66 VSS.t59 4534.88
R341 VSS.t65 VSS.t66 4534.88
R342 VSS.t61 VSS.t28 4534.88
R343 VSS.t28 VSS.t84 4534.88
R344 VSS.n73 VSS.n72 4522.94
R345 VSS.n72 VSS.n71 4477.18
R346 VSS.t10 VSS.t8 3930.23
R347 VSS.n38 VSS.n19 3603.73
R348 VSS.n76 VSS.n19 3575
R349 VSS.t8 VSS.t36 3522.09
R350 VSS.n71 VSS.t86 3074.69
R351 VSS.t86 VSS.n70 2724.07
R352 VSS.n70 VSS.t6 2670.12
R353 VSS.n66 VSS.t4 2670.12
R354 VSS.t36 VSS.t26 2569.77
R355 VSS.n72 VSS.n34 2317.76
R356 VSS.n66 VSS.n33 2245.33
R357 VSS.n82 VSS.n12 1907.24
R358 VSS.n104 VSS.n103 1777.31
R359 VSS.t75 VSS.t70 1402.31
R360 VSS.t38 VSS.t46 1402.31
R361 VSS.t40 VSS.t34 1083.33
R362 VSS.t48 VSS.t56 1083.33
R363 VSS.t77 VSS.t0 1083.33
R364 VSS.t50 VSS.t68 1083.33
R365 VSS.n74 VSS.n31 855.996
R366 VSS.n58 VSS.n38 745.014
R367 VSS.n59 VSS.t31 744.856
R368 VSS.n59 VSS.n41 628.832
R369 VSS.t44 VSS.n84 489.034
R370 VSS.n41 VSS.t2 394.214
R371 VSS.n59 VSS.t52 394.214
R372 VSS.t54 VSS.n58 394.214
R373 VSS.n59 VSS.t32 394.214
R374 VSS.n40 VSS.t63 370.908
R375 VSS.n84 VSS.t17 352.812
R376 VSS.n35 VSS.n33 269.711
R377 VSS.n59 VSS.n40 264.5
R378 VSS.t2 VSS.t40 261.807
R379 VSS.t34 VSS.t75 261.807
R380 VSS.t70 VSS.t48 261.807
R381 VSS.t56 VSS.t52 261.807
R382 VSS.t0 VSS.t54 261.807
R383 VSS.t46 VSS.t77 261.807
R384 VSS.t68 VSS.t38 261.807
R385 VSS.t32 VSS.t50 261.807
R386 VSS.t73 VSS.t82 234.007
R387 VSS.t82 VSS.t85 234.007
R388 VSS.n12 VSS.t17 214.208
R389 VSS.n35 VSS.t6 209.025
R390 VSS.n81 VSS.n14 203.779
R391 VSS.n77 VSS.n14 200.862
R392 VSS.t11 VSS.t19 197.102
R393 VSS.n76 VSS.n75 196.712
R394 VSS.n18 VSS.n13 191.917
R395 VSS.n81 VSS.n13 191.917
R396 VSS.n32 VSS.t61 166.28
R397 VSS.t25 VSS.n30 165.032
R398 VSS.t21 VSS.t42 159.435
R399 VSS.t80 VSS.t44 131.403
R400 VSS.t13 VSS.t12 131.403
R401 VSS.t15 VSS.t11 131.403
R402 VSS.n30 VSS.n25 126.594
R403 VSS.t42 VSS.n89 125.27
R404 VSS.t19 VSS.n95 125.27
R405 VSS.t89 VSS.n102 125.27
R406 VSS.t12 VSS.n90 118.7
R407 VSS.n74 VSS.n73 105.421
R408 VSS.n25 VSS.n20 96.9021
R409 VSS.n31 VSS.t25 81.941
R410 VSS.n61 VSS.t23 81.0297
R411 VSS.t73 VSS.n36 79.2029
R412 VSS.n83 VSS.t23 53.3274
R413 VSS.n57 VSS.n41 50.5892
R414 VSS.n104 VSS.n11 36.7126
R415 VSS.t29 VSS.n11 29.8075
R416 VSS.n60 VSS.n59 28.7416
R417 VSS.n31 VSS.n19 26.8728
R418 VSS.n64 VSS.t73 25.1405
R419 VSS.n64 VSS.t18 24.7701
R420 VSS.n40 VSS.n39 24.0907
R421 VSS.n70 VSS.n69 23.9005
R422 VSS.n67 VSS.n66 23.9005
R423 VSS.n42 VSS.t71 23.4006
R424 VSS.n50 VSS.t47 23.4006
R425 VSS.n51 VSS.t33 23.3466
R426 VSS.n67 VSS.t5 22.7255
R427 VSS.n39 VSS.t64 22.6744
R428 VSS.n65 VSS.t87 22.3205
R429 VSS.n68 VSS.t7 22.3205
R430 VSS.t85 VSS.n12 19.8011
R431 VSS.n111 VSS.n6 19.5545
R432 VSS.n110 VSS.n7 19.1555
R433 VSS.n53 VSS.t39 18.5991
R434 VSS.n48 VSS.t3 18.5991
R435 VSS.n45 VSS.t76 18.5991
R436 VSS.n51 VSS.t69 18.56
R437 VSS.n47 VSS.t35 18.56
R438 VSS.n52 VSS.t51 18.506
R439 VSS.n42 VSS.t57 18.506
R440 VSS.n46 VSS.t41 18.506
R441 VSS.n39 VSS.t24 18.0491
R442 VSS.n117 VSS.n0 16.4377
R443 VSS.n114 VSS.n3 16.213
R444 VSS.n21 VSS.t62 16.1466
R445 VSS.n26 VSS.t60 16.1466
R446 VSS.n87 VSS.t43 16.1466
R447 VSS.n93 VSS.t20 16.122
R448 VSS.n98 VSS.t90 16.0975
R449 VSS.n57 VSS.n56 15.556
R450 VSS.n109 VSS.n108 14.9947
R451 VSS.n113 VSS.n4 14.903
R452 VSS.n115 VSS.n2 14.903
R453 VSS.n62 VSS.n61 14.9005
R454 VSS.n109 VSS.n8 14.8985
R455 VSS.n112 VSS.n5 14.8985
R456 VSS.n116 VSS.n1 14.8985
R457 VSS.n90 VSS.t21 14.8927
R458 VSS.n56 VSS.t55 14.0991
R459 VSS.n37 VSS.t53 14.0991
R460 VSS.n54 VSS.t78 13.8305
R461 VSS.n49 VSS.t1 13.8305
R462 VSS.n44 VSS.t49 13.8305
R463 VSS.n63 VSS.n15 13.7986
R464 VSS.n6 VSS.t30 13.3665
R465 VSS.n7 VSS.t9 13.3208
R466 VSS VSS.n117 12.0597
R467 VSS.n96 VSS.t79 12.0546
R468 VSS.n91 VSS.t72 12.0546
R469 VSS.n22 VSS.t88 12.0546
R470 VSS.n27 VSS.t83 12.0546
R471 VSS.n85 VSS.t45 12.0546
R472 VSS.n117 VSS.n116 11.3326
R473 VSS.n96 VSS.t16 11.2798
R474 VSS.n91 VSS.t14 11.2798
R475 VSS.n22 VSS.t58 11.2798
R476 VSS.n27 VSS.t67 11.2798
R477 VSS.n85 VSS.t81 11.2798
R478 VSS.n3 VSS.t22 11.0891
R479 VSS.n10 VSS.t37 10.9509
R480 VSS.n107 VSS.t27 10.9058
R481 VSS.n63 VSS.n62 9.2525
R482 VSS.n56 VSS.n55 9.248
R483 VSS.n37 VSS.n0 9.00997
R484 VSS.n89 VSS.t80 6.13258
R485 VSS.n95 VSS.t13 6.13258
R486 VSS.n102 VSS.t15 6.13258
R487 VSS.n78 VSS.n77 5.2005
R488 VSS.n77 VSS.n76 5.2005
R489 VSS.n18 VSS.n17 5.2005
R490 VSS.n75 VSS.n18 5.2005
R491 VSS.n77 VSS.n18 4.86161
R492 VSS.n53 VSS.n52 4.802
R493 VSS.n46 VSS.n45 4.802
R494 VSS.n48 VSS.n47 4.748
R495 VSS.n44 VSS.n43 4.73
R496 VSS.n55 VSS.n54 4.73
R497 VSS.n50 VSS.n49 4.676
R498 VSS.n100 VSS.n99 4.5005
R499 VSS.n106 VSS.n9 4.5005
R500 VSS.n64 VSS.n63 2.84725
R501 VSS.n11 VSS.n7 2.6005
R502 VSS.n20 VSS.n6 2.6005
R503 VSS.n80 VSS.n79 2.48024
R504 VSS.n79 VSS.n78 2.44471
R505 VSS.n17 VSS.n16 2.33576
R506 VSS.n100 VSS.n98 2.2987
R507 VSS.n108 VSS.n107 2.26612
R508 VSS.n61 VSS.n60 2.07817
R509 VSS.n86 VSS.n1 1.57622
R510 VSS.n23 VSS.n4 1.56045
R511 VSS.n28 VSS.n2 1.56045
R512 VSS.n10 VSS.n9 1.5602
R513 VSS.n16 VSS.n15 1.55892
R514 VSS.n94 VSS.n93 1.55407
R515 VSS.n49 VSS.n48 1.40765
R516 VSS.n90 VSS.n3 1.31114
R517 VSS.n99 VSS.n97 1.21383
R518 VSS.n92 VSS.n5 1.17783
R519 VSS.n24 VSS.n21 1.13798
R520 VSS.n29 VSS.n26 1.13798
R521 VSS.n88 VSS.n87 1.13798
R522 VSS.n45 VSS.n44 0.951118
R523 VSS.n105 VSS.n104 0.867167
R524 VSS.n112 VSS.n111 0.79475
R525 VSS.n80 VSS.n15 0.772605
R526 VSS.n58 VSS.n57 0.770886
R527 VSS.n52 VSS.n51 0.761
R528 VSS.n43 VSS.n42 0.761
R529 VSS.n47 VSS.n46 0.761
R530 VSS.n55 VSS.n50 0.761
R531 VSS.n62 VSS.n37 0.689955
R532 VSS.n115 VSS.n114 0.6755
R533 VSS.n30 VSS.n29 0.6505
R534 VSS.n25 VSS.n24 0.6505
R535 VSS.n95 VSS.n94 0.6505
R536 VSS.n102 VSS.n101 0.6505
R537 VSS.n89 VSS.n88 0.6505
R538 VSS.n54 VSS.n53 0.638102
R539 VSS.n114 VSS.n113 0.563
R540 VSS.n65 VSS.n64 0.556468
R541 VSS.n68 VSS.n67 0.413682
R542 VSS.n69 VSS.n68 0.4055
R543 VSS.n20 VSS.t29 0.345755
R544 VSS.n69 VSS.n65 0.331864
R545 VSS.n111 VSS.n110 0.29525
R546 VSS.n81 VSS.n80 0.274184
R547 VSS.n82 VSS.n81 0.274184
R548 VSS.n43 VSS.n0 0.228757
R549 VSS.n16 VSS.n13 0.217167
R550 VSS.n60 VSS.n13 0.217167
R551 VSS.n79 VSS.n14 0.2085
R552 VSS.n71 VSS.n14 0.2085
R553 VSS.n110 VSS.n109 0.149
R554 VSS.n97 VSS.n96 0.113439
R555 VSS.n92 VSS.n91 0.113439
R556 VSS.n116 VSS.n115 0.113
R557 VSS.n113 VSS.n112 0.113
R558 VSS.n21 VSS.n4 0.103094
R559 VSS.n26 VSS.n2 0.103094
R560 VSS.n23 VSS.n22 0.0983236
R561 VSS.n28 VSS.n27 0.0983236
R562 VSS.n86 VSS.n85 0.0983224
R563 VSS.n87 VSS.n1 0.0868944
R564 VSS.n93 VSS.n5 0.0840305
R565 VSS.n98 VSS.n8 0.0632998
R566 VSS.n78 VSS.n17 0.0597105
R567 VSS.n88 VSS.n86 0.0569545
R568 VSS.n24 VSS.n23 0.0569533
R569 VSS.n29 VSS.n28 0.0569533
R570 VSS.n108 VSS.n9 0.0565154
R571 VSS.n101 VSS.n100 0.0482
R572 VSS.n106 VSS.n105 0.0482
R573 VSS.n101 VSS.n97 0.0423191
R574 VSS.n94 VSS.n92 0.0423191
R575 VSS.n105 VSS.n10 0.0419054
R576 VSS.n107 VSS.n106 0.0365
R577 VSS.n99 VSS.n8 0.0095
R578 a_75155_31132.t0 a_75155_31132.t1 5.8505
R579 a_74555_31124.t0 a_74555_31124.t1 5.8505
R580 a_72617_31132.t0 a_72617_31132.t1 5.8505
R581 a_72017_31124.t0 a_72017_31124.t1 5.8505
R582 a_70517_31132.t0 a_70517_31132.t1 5.8505
R583 a_69917_31124.t0 a_69917_31124.t1 5.8505
R584 a_73893_31678.t0 a_73893_31678.n0 11.1781
R585 a_73893_31678.n0 a_73893_31678.t2 27.9967
R586 a_73893_31678.n0 a_73893_31678.t1 5.57145
R587 a_74493_31748.t0 a_74493_31748.n0 11.1272
R588 a_74493_31748.n0 a_74493_31748.t1 5.5871
R589 a_74493_31748.n0 a_74493_31748.n1 5.20121
R590 a_74493_31748.n1 a_74493_31748.t3 39.0221
R591 a_74493_31748.n1 a_74493_31748.t2 31.9469
R592 a_73893_31864.t0 a_73893_31864.t1 3.2505
R593 a_73225_31738.t0 a_73225_31738.n0 11.6086
R594 a_73225_31738.n0 a_73225_31738.n2 10.0243
R595 a_73225_31738.n2 a_73225_31738.n3 1.39941
R596 a_73225_31738.n3 a_73225_31738.t3 30.1998
R597 a_73225_31738.n3 a_73225_31738.t5 34.9895
R598 a_73225_31738.n2 a_73225_31738.n1 1.0042
R599 a_73225_31738.n1 a_73225_31738.t4 34.3028
R600 a_73225_31738.n1 a_73225_31738.t2 30.5324
R601 a_73225_31738.n0 a_73225_31738.t1 5.2255
R602 a_71355_31678.t1 a_71355_31678.n0 11.1781
R603 a_71355_31678.n0 a_71355_31678.t2 27.9967
R604 a_71355_31678.n0 a_71355_31678.t0 5.57145
R605 a_71955_31748.t1 a_71955_31748.n0 11.1272
R606 a_71955_31748.n0 a_71955_31748.t0 5.5871
R607 a_71955_31748.n0 a_71955_31748.n1 5.20121
R608 a_71955_31748.n1 a_71955_31748.t3 39.0221
R609 a_71955_31748.n1 a_71955_31748.t2 31.9469
R610 a_71355_31864.t0 a_71355_31864.t1 3.2505
R611 a_69255_31678.t1 a_69255_31678.n0 11.1781
R612 a_69255_31678.n0 a_69255_31678.t2 27.9967
R613 a_69255_31678.n0 a_69255_31678.t0 5.57145
R614 a_70517_31292.t0 a_70517_31292.n0 10.8005
R615 a_70517_31292.n0 a_70517_31292.t1 6.05863
R616 a_70517_31292.n0 a_70517_31292.n1 5.54412
R617 a_70517_31292.n1 a_70517_31292.t2 31.7187
R618 a_70517_31292.n1 a_70517_31292.t3 39.4494
R619 a_69855_31748.t1 a_69855_31748.n0 11.1272
R620 a_69855_31748.n0 a_69855_31748.t0 5.5871
R621 a_69855_31748.n0 a_69855_31748.n1 5.20121
R622 a_69855_31748.n1 a_69855_31748.t3 39.0221
R623 a_69855_31748.n1 a_69855_31748.t2 31.9469
R624 a_69255_31864.t0 a_69255_31864.t1 3.2505
R625 a_76557_31872.t0 a_76557_31872.t1 22.3309
R626 a_78030_32132.t0 a_78030_32132.t1 22.3309
R627 a_76557_32392.t0 a_76557_32392.t1 22.3309
R628 a_74957_32984.t0 a_74957_32984.t1 3.2505
R629 a_70530_32714.t0 a_70530_32714.t1 5.05606
R630 a_72757_32984.t0 a_72757_32984.t1 3.2505
R631 a_69317_32762.t0 a_69317_32762.t1 10.9468
R632 a_70565_33412.t0 a_70565_33412.t1 9.1005
R633 a_76168_33670.t0 a_76168_33670.n0 9.02789
R634 a_76168_33670.n0 a_76168_33670.n1 1.18224
R635 a_76168_33670.n1 a_76168_33670.t3 45.9855
R636 a_76168_33670.n1 a_76168_33670.t2 32.9263
R637 a_76168_33670.n0 a_76168_33670.t1 3.50267
R638 a_74347_33668.t1 a_74347_33668.n0 11.1781
R639 a_74347_33668.n0 a_74347_33668.t2 27.9967
R640 a_74347_33668.n0 a_74347_33668.t0 5.57145
R641 a_74407_33724.t0 a_74407_33724.t1 5.8505
R642 a_73807_33716.t0 a_73807_33716.t1 5.8505
R643 a_70565_33580.t0 a_70565_33580.t1 9.1005
R644 a_69985_32940.t0 a_69985_32940.n0 13.2969
R645 a_69985_32940.n0 a_69985_32940.n1 0.544413
R646 a_69985_32940.n1 a_69985_32940.t3 22.2917
R647 a_69985_32940.n1 a_69985_32940.t2 21.7791
R648 a_69985_32940.n0 a_69985_32940.t1 9.53231
R649 a_72147_33668.t0 a_72147_33668.n0 11.1781
R650 a_72147_33668.n0 a_72147_33668.t2 27.9967
R651 a_72147_33668.n0 a_72147_33668.t1 5.57145
R652 a_73597_33018.t0 a_73597_33018.n0 11.1272
R653 a_73597_33018.n0 a_73597_33018.t1 5.5871
R654 a_73597_33018.n0 a_73597_33018.n1 5.20121
R655 a_73597_33018.n1 a_73597_33018.t3 31.9469
R656 a_73597_33018.n1 a_73597_33018.t2 39.0221
R657 a_72207_33724.t0 a_72207_33724.t1 5.8505
R658 a_71607_33716.t0 a_71607_33716.t1 5.8505
R659 a_70045_33584.t0 a_70045_33584.t1 9.1005
R660 a_70505_33684.t1 a_70505_33684.n0 11.6336
R661 a_70505_33684.n0 a_70505_33684.n3 9.2525
R662 a_70505_33684.n3 a_70505_33684.n6 9.61657
R663 a_70505_33684.n6 a_70505_33684.n5 1.3955
R664 a_70505_33684.n5 a_70505_33684.t5 34.3028
R665 a_70505_33684.n5 a_70505_33684.t7 30.5324
R666 a_70505_33684.n6 a_70505_33684.n4 1.00811
R667 a_70505_33684.n4 a_70505_33684.t6 30.1998
R668 a_70505_33684.n4 a_70505_33684.t4 34.9895
R669 a_70505_33684.n3 a_70505_33684.n2 2.3405
R670 a_70505_33684.n2 a_70505_33684.t8 39.1187
R671 a_70505_33684.n2 a_70505_33684.n1 4.52407
R672 a_70505_33684.n1 a_70505_33684.t2 32.5951
R673 a_70505_33684.n1 a_70505_33684.t3 38.5719
R674 a_70505_33684.n0 a_70505_33684.t0 5.2255
R675 a_70565_33748.t0 a_70565_33748.t1 9.1005
R676 a_71397_33018.t1 a_71397_33018.n0 11.1272
R677 a_71397_33018.n0 a_71397_33018.t0 5.5871
R678 a_71397_33018.n0 a_71397_33018.n1 5.20121
R679 a_71397_33018.n1 a_71397_33018.t3 31.9469
R680 a_71397_33018.n1 a_71397_33018.t2 39.0221
R681 a_69119_31958.t1 a_69119_31958.n2 11.0744
R682 a_69119_31958.n2 a_69119_31958.n0 0.530717
R683 a_69119_31958.n0 a_69119_31958.n1 15.4758
R684 a_69119_31958.n1 a_69119_31958.t3 32.593
R685 a_69119_31958.n1 a_69119_31958.t4 38.5719
R686 a_69119_31958.n0 a_69119_31958.t0 5.2255
R687 a_69119_31958.n2 a_69119_31958.t2 11.1292
R688 a_69257_32706.t0 a_69257_32706.n0 13.3959
R689 a_69257_32706.n0 a_69257_32706.n1 0.614848
R690 a_69257_32706.n1 a_69257_32706.t3 27.7991
R691 a_69257_32706.n1 a_69257_32706.t2 35.2576
R692 a_69257_32706.n0 a_69257_32706.t1 13.3477
R693 a_70505_33852.t0 a_70505_33852.n0 10.8005
R694 a_70505_33852.n0 a_70505_33852.t1 6.05863
R695 a_70505_33852.n0 a_70505_33852.n6 9.0005
R696 a_70505_33852.n6 a_70505_33852.n5 6.701
R697 a_70505_33852.n5 a_70505_33852.t5 32.593
R698 a_70505_33852.n5 a_70505_33852.t2 38.5719
R699 a_70505_33852.n6 a_70505_33852.n4 0.49775
R700 a_70505_33852.n4 a_70505_33852.t8 34.7842
R701 a_70505_33852.n4 a_70505_33852.n3 10.4382
R702 a_70505_33852.n3 a_70505_33852.n2 1.18399
R703 a_70505_33852.n2 a_70505_33852.t4 34.3028
R704 a_70505_33852.n2 a_70505_33852.t7 30.5324
R705 a_70505_33852.n3 a_70505_33852.n1 1.2155
R706 a_70505_33852.n1 a_70505_33852.t6 30.1998
R707 a_70505_33852.n1 a_70505_33852.t3 34.9895
R708 a_70565_33916.t0 a_70565_33916.t1 9.1005
R709 a_69087_33798.t0 a_69087_33798.n5 11.2955
R710 a_69087_33798.n5 a_69087_33798.n0 0.712674
R711 a_69087_33798.n5 a_69087_33798.n1 0.338627
R712 a_69087_33798.n1 a_69087_33798.n3 13.7769
R713 a_69087_33798.n3 a_69087_33798.n4 7.39062
R714 a_69087_33798.n4 a_69087_33798.t7 32.548
R715 a_69087_33798.n4 a_69087_33798.t5 39.0552
R716 a_69087_33798.n3 a_69087_33798.n2 9.0005
R717 a_69087_33798.n2 a_69087_33798.t6 23.5336
R718 a_69087_33798.n2 a_69087_33798.t4 26.7067
R719 a_69087_33798.n1 a_69087_33798.t1 5.2255
R720 a_69087_33798.n0 a_69087_33798.t3 34.6334
R721 a_69087_33798.n0 a_69087_33798.t2 27.3491
R722 a_70565_34084.t0 a_70565_34084.t1 9.1005
R723 a_76557_34092.t0 a_76557_34092.t1 22.3309
R724 a_78030_34352.t0 a_78030_34352.t1 22.3309
R725 a_76968_33670.t0 a_76968_33670.n2 22.8339
R726 a_76968_33670.n2 a_76968_33670.n1 0.593326
R727 a_76968_33670.n1 a_76968_33670.t1 3.49875
R728 a_76968_33670.n1 a_76968_33670.t2 9.0318
R729 a_76968_33670.n2 a_76968_33670.n0 0.522891
R730 a_76968_33670.n0 a_76968_33670.t4 45.9816
R731 a_76968_33670.n0 a_76968_33670.t3 32.9302
R732 a_76557_34612.t0 a_76557_34612.t1 22.3309
R733 a_80630_35072.t0 a_80630_35072.n0 9.3742
R734 a_80630_35072.n0 a_80630_35072.t2 9.2118
R735 a_80630_35072.n0 a_80630_35072.t1 9.41333
R736 a_80362_35700.t0 a_80362_35700.n0 9.01615
R737 a_80362_35700.n0 a_80362_35700.n1 1.10007
R738 a_80362_35700.n1 a_80362_35700.t3 56.5567
R739 a_80362_35700.n1 a_80362_35700.t1 45.5434
R740 a_80362_35700.n0 a_80362_35700.t2 3.40583
R741 a_79278_35710.t0 a_79278_35710.n0 9.02789
R742 a_79278_35710.n0 a_79278_35710.n1 0.978761
R743 a_79278_35710.n1 a_79278_35710.t3 72.0569
R744 a_79278_35710.n1 a_79278_35710.t2 45.9621
R745 a_79278_35710.n0 a_79278_35710.t1 3.39409
C0 O1N VTUNE 0.16219f
C1 m2_88815_30927# m1_93127_31487# 2.46348f
C2 VTUNE VDD 0.29727f
C3 m3_67067_36907# m3_67067_37131# 0.14474f
C4 O3N O2P 0.48024f
C5 O4P O3P 0.16393f
C6 m2_53875_30411# m2_53651_30411# 0.11024f
C7 O1N O4N 0.28447f
C8 O3N O1P 0.40929f
C9 MIM_TOP CORE_CLK 0.07778f
C10 O2N O1N 0.54452f
C11 O4N VDD 0.02356f
C12 O1P O2P 0.44372f
C13 VTUNE O4N 0.1564f
C14 O2N VTUNE 0.18479f
C15 m2_88815_30927# VDD 0.63527f
C16 O1N O4P 0.28492f
C17 O1P DOUBLER_K 0.63794f
C18 m3_67067_37131# m3_67067_38475# 0.01977f
C19 MC CORE_CLK 0.14547f
C20 O3P VDD_VCO 0.97028f
C21 O4P VTUNE 0.12676f
C22 m1_92517_31205# m1_89445_31117# 0.07042f
C23 O2N O4N 0.27348f
C24 MC PRESCALED 0.59412f
C25 O1N MIM_TOP 0.12285f
C26 m2_53875_30411# m2_60395_30411# 0.01006f
C27 MIM_TOP VDD 0.47286f
C28 m1_89445_31117# m1_93127_31487# 0.04328f
C29 m3_56811_35563# PRESCALED 2.96246f
C30 O3N O3P 0.58197f
C31 m2_53875_30411# m2_53427_30411# 0.03019f
C32 O4P O4N 0.80419f
C33 PRESCALED m2_60395_30411# 0.29676f
C34 MIM_TOP VTUNE 0.07224f
C35 O2N O4P 0.10282f
C36 O1N VDD_VCO 0.99028f
C37 O1P CORE_CLK 0.08052f
C38 O3P O2P 0.19234f
C39 VDD_VCO VDD 0.05276f
C40 MC VDD 0.13708f
C41 VTUNE VDD_VCO 0.11802f
C42 MIM_TOP O4N 0.01408f
C43 O1P O3P 0.14199f
C44 m3_56811_35563# VDD 0.32616f
C45 m2_60395_30411# VDD 0.43394f
C46 O1N O3N 0.34472f
C47 m3_56811_37355# PRESCALED 0.05433f
C48 m1_89445_31117# VDD 0.04159f
C49 O3N VDD 0.02395f
C50 O4N VDD_VCO 0.70731f
C51 O3N VTUNE 0.10116f
C52 O1N O2P 0.40474f
C53 O2N VDD_VCO 0.66967f
C54 m3_54899_75435# m3_54899_75659# 0.14474f
C55 O1N O1P 1.69187f
C56 O1N DOUBLER_K 0.65913f
C57 TAIL_BIAS O1N 0.04792f
C58 VTUNE O2P 0.11332f
C59 m1_92517_31205# m1_93127_31487# 0.0212f
C60 O1P VDD 0.09833f
C61 VDD DOUBLER_K 0.03533f
C62 TAIL_BIAS VDD 0.02008f
C63 O4P VDD_VCO 0.84736f
C64 O3N O4N 0.21736f
C65 O1P VTUNE 0.14675f
C66 VTUNE DOUBLER_K 0.12369f
C67 m3_56811_35563# m2_88815_30927# 0.29992f
C68 O2N O3N 0.13588f
C69 m2_46259_30411# m2_46035_30411# 0.16767f
C70 m2_63979_42907# m2_63755_42907# 0.16767f
C71 PRESCALED CORE_CLK 0.11764f
C72 O4N O2P 0.11072f
C73 m1_89445_31117# m2_88815_30927# 0.77042f
C74 RF_OUT VDD 0.1705f
C75 O2N O2P 0.60415f
C76 O1P O4N 0.71531f
C77 O3N O4P 0.19187f
C78 O4N DOUBLER_K 0.02762f
C79 O2N O1P 0.03294f
C80 m2_87683_31443# VDD 0.14232f
C81 m2_53651_30411# m2_53427_30411# 0.11024f
C82 O1N CORE_CLK 0.01423f
C83 O4P O2P 0.446f
C84 CORE_CLK VDD 5.75701f
C85 O1N O3P 0.40898f
C86 O4P O1P 0.51196f
C87 m1_93127_31487# VDD 3.61898f
C88 VTUNE CORE_CLK 0.14672f
C89 m3_56811_35563# MC 0.08167f
C90 VTUNE O3P 0.23071f
C91 PRESCALED VDD 0.73843f
C92 O3N VDD_VCO 0.8853f
C93 m2_46259_30411# m2_46483_30411# 0.16767f
C94 O1P MIM_TOP 0.05925f
C95 MIM_TOP DOUBLER_K 0.50166f
C96 m3_56811_35563# m2_60395_30411# 0.06515f
C97 m3_56811_35563# m1_89445_31117# 0.57166f
C98 O2P VDD_VCO 0.97439f
C99 O4N O3P 0.08566f
C100 O1N VDD 0.11052f
C101 O2N O3P 0.28462f
C102 O1P VDD_VCO 1.09063f
C103 TAIL_BIAS VDD_VCO 0.03936f
C104 O2N VSS 2.62897f
C105 O4P VSS 1.79609f
C106 O3N VSS 2.20705f
C107 O2P VSS 1.94936f
C108 O4N VSS 2.7999f
C109 O3P VSS 3.99628f
C110 RF_OUT VSS 0.4449f
C111 PRESCALED VSS 11.06882f
C112 MIM_TOP VSS 1.54716f
C113 MC VSS 3.57822f
C114 TAIL_BIAS VSS 0.51005f
C115 O1N VSS 3.96832f
C116 VTUNE VSS 7.44639f
C117 O1P VSS 3.81137f
C118 CORE_CLK VSS 8.84473f
C119 VDD_VCO VSS 12.37607f
C120 VDD VSS 88.04027f
C121 DOUBLER_K VSS 2.47628f
C122 m3_56811_35563# VSS 12.2477f $ **FLOATING
C123 m3_67067_36907# VSS 0.18118f $ **FLOATING
C124 m3_67067_37131# VSS 0.12922f $ **FLOATING
C125 m3_56811_37355# VSS 0.19557f $ **FLOATING
C126 m3_67067_38475# VSS 0.17594f $ **FLOATING
C127 m3_54899_63787# VSS 0.20286f $ **FLOATING
C128 m3_54899_75435# VSS 0.18118f $ **FLOATING
C129 m3_54899_75659# VSS 0.15614f $ **FLOATING
C130 m3_1011_87083# VSS 0.20286f $ **FLOATING
C131 m2_88815_30927# VSS 2.33858f $ **FLOATING
C132 m2_87683_31443# VSS 0.22994f $ **FLOATING
C133 m2_60395_30411# VSS 6.09306f $ **FLOATING
C134 m2_53875_30411# VSS 0.19848f $ **FLOATING
C135 m2_53651_30411# VSS 0.25461f $ **FLOATING
C136 m2_53427_30411# VSS 0.2042f $ **FLOATING
C137 m2_51187_30411# VSS 0.26379f $ **FLOATING
C138 m2_48947_30371# VSS 0.2773f $ **FLOATING
C139 m2_46483_30411# VSS 0.22896f $ **FLOATING
C140 m2_46259_30411# VSS 0.14418f $ **FLOATING
C141 m2_46035_30411# VSS 0.22896f $ **FLOATING
C142 m2_63979_42907# VSS 0.22896f $ **FLOATING
C143 m2_63755_42907# VSS 0.20399f $ **FLOATING
C144 m2_5043_90299# VSS 0.26379f $ **FLOATING
C145 m1_113640_29695# VSS 55.2516f $ **FLOATING
C146 m1_89445_31117# VSS 2.34672f $ **FLOATING
C147 m1_92517_31205# VSS 0.36445f $ **FLOATING
C148 m1_93127_31487# VSS 12.743f $ **FLOATING
C149 a_79278_35710.t0 VSS 0.08148f
C150 a_79278_35710.t1 VSS 0.15509f
C151 a_79278_35710.n0 VSS 0.26912f
C152 a_79278_35710.t2 VSS 0.07409f
C153 a_79278_35710.t3 VSS 0.14227f
C154 a_79278_35710.n1 VSS 0.27455f
C155 a_80362_35700.t0 VSS 0.07453f
C156 a_80362_35700.t2 VSS 0.1425f
C157 a_80362_35700.n0 VSS 0.25304f
C158 a_80362_35700.t1 VSS 0.06762f
C159 a_80362_35700.n1 VSS 0.42204f
C160 a_80362_35700.t3 VSS 0.10813f
C161 a_80630_35072.t0 VSS 0.04253f
C162 a_80630_35072.t1 VSS 0.04272f
C163 a_80630_35072.t2 VSS 0.04182f
C164 a_80630_35072.n0 VSS 0.12732f
C165 a_76557_34612.t0 VSS 0.02636f
C166 a_76557_34612.t1 VSS 0.02636f
C167 a_76968_33670.t0 VSS 0.17682f
C168 a_76968_33670.t3 VSS 0.03467f
C169 a_76968_33670.t4 VSS 0.06373f
C170 a_76968_33670.n0 VSS 0.18551f
C171 a_76968_33670.t2 VSS 0.06961f
C172 a_76968_33670.t1 VSS 0.13536f
C173 a_76968_33670.n1 VSS 0.21141f
C174 a_76968_33670.n2 VSS 0.36054f
C175 a_78030_34352.t0 VSS 0.06834f
C176 a_78030_34352.t1 VSS 0.06834f
C177 a_76557_34092.t0 VSS 0.03621f
C178 a_76557_34092.t1 VSS 0.03621f
C179 a_69087_33798.t0 VSS 0.07285f
C180 a_69087_33798.t2 VSS 0.04528f
C181 a_69087_33798.t3 VSS 0.07771f
C182 a_69087_33798.n0 VSS 0.40485f
C183 a_69087_33798.t1 VSS 0.13341f
C184 a_69087_33798.n1 VSS 0.42968f
C185 a_69087_33798.n2 VSS 0.33271f
C186 a_69087_33798.t4 VSS 0.06083f
C187 a_69087_33798.t6 VSS 0.04202f
C188 a_69087_33798.n3 VSS 1.64763f
C189 a_69087_33798.n4 VSS 0.69679f
C190 a_69087_33798.t5 VSS 0.10046f
C191 a_69087_33798.t7 VSS 0.07725f
C192 a_69087_33798.n5 VSS 0.23201f
C193 a_70505_33852.t0 VSS 0.05172f
C194 a_70505_33852.n0 VSS 0.27557f
C195 a_70505_33852.t3 VSS 0.06043f
C196 a_70505_33852.n1 VSS 0.70919f
C197 a_70505_33852.t6 VSS 0.06332f
C198 a_70505_33852.t7 VSS 0.06923f
C199 a_70505_33852.n2 VSS 0.67209f
C200 a_70505_33852.t4 VSS 0.05776f
C201 a_70505_33852.n3 VSS 0.24188f
C202 a_70505_33852.t8 VSS 0.11274f
C203 a_70505_33852.n4 VSS 1.92071f
C204 a_70505_33852.n5 VSS 0.5669f
C205 a_70505_33852.t2 VSS 0.06552f
C206 a_70505_33852.t5 VSS 0.04949f
C207 a_70505_33852.n6 VSS 0.84275f
C208 a_70505_33852.t1 VSS 0.12545f
C209 a_69257_32706.t0 VSS 0.04539f
C210 a_69257_32706.t1 VSS 0.0466f
C211 a_69257_32706.n0 VSS 0.28404f
C212 a_69257_32706.t2 VSS 0.09047f
C213 a_69257_32706.t3 VSS 0.05358f
C214 a_69257_32706.n1 VSS 0.63175f
C215 a_69119_31958.t1 VSS 0.04546f
C216 a_69119_31958.t2 VSS 0.0458f
C217 a_69119_31958.n0 VSS 0.34305f
C218 a_69119_31958.t0 VSS 0.08622f
C219 a_69119_31958.n1 VSS 0.81569f
C220 a_69119_31958.t4 VSS 0.05592f
C221 a_69119_31958.t3 VSS 0.04223f
C222 a_69119_31958.n2 VSS 0.16798f
C223 a_71397_33018.t1 VSS 0.0553f
C224 a_71397_33018.n0 VSS 0.28411f
C225 a_71397_33018.t2 VSS 0.06908f
C226 a_71397_33018.t3 VSS 0.04526f
C227 a_71397_33018.n1 VSS 0.5496f
C228 a_71397_33018.t0 VSS 0.11362f
C229 a_70505_33684.t1 VSS 0.0847f
C230 a_70505_33684.t0 VSS 0.14466f
C231 a_70505_33684.n0 VSS 0.4196f
C232 a_70505_33684.t3 VSS 0.09382f
C233 a_70505_33684.n1 VSS 0.61155f
C234 a_70505_33684.t2 VSS 0.07089f
C235 a_70505_33684.n2 VSS 2.24857f
C236 a_70505_33684.t8 VSS 0.28753f
C237 a_70505_33684.n3 VSS 0.88549f
C238 a_70505_33684.t4 VSS 0.08652f
C239 a_70505_33684.n4 VSS 0.99721f
C240 a_70505_33684.t6 VSS 0.09066f
C241 a_70505_33684.t7 VSS 0.09913f
C242 a_70505_33684.n5 VSS 0.982f
C243 a_70505_33684.t5 VSS 0.0827f
C244 a_70505_33684.n6 VSS 0.29723f
C245 a_73597_33018.t0 VSS 0.0509f
C246 a_73597_33018.n0 VSS 0.26148f
C247 a_73597_33018.t2 VSS 0.06358f
C248 a_73597_33018.t3 VSS 0.04165f
C249 a_73597_33018.n1 VSS 0.50583f
C250 a_73597_33018.t1 VSS 0.10457f
C251 a_72147_33668.t0 VSS 0.04358f
C252 a_72147_33668.t1 VSS 0.08853f
C253 a_72147_33668.n0 VSS 0.37251f
C254 a_72147_33668.t2 VSS 0.03092f
C255 a_69985_32940.t0 VSS 0.04312f
C256 a_69985_32940.t1 VSS 0.09654f
C257 a_69985_32940.n0 VSS 0.25845f
C258 a_69985_32940.t2 VSS 0.04501f
C259 a_69985_32940.t3 VSS 0.04743f
C260 a_69985_32940.n1 VSS 0.41967f
C261 a_74347_33668.t1 VSS 0.04297f
C262 a_74347_33668.t0 VSS 0.08728f
C263 a_74347_33668.n0 VSS 0.36728f
C264 a_74347_33668.t2 VSS 0.03049f
C265 a_76168_33670.t0 VSS 0.07207f
C266 a_76168_33670.t1 VSS 0.14035f
C267 a_76168_33670.n0 VSS 0.2435f
C268 a_76168_33670.t2 VSS 0.0359f
C269 a_76168_33670.t3 VSS 0.06602f
C270 a_76168_33670.n1 VSS 0.21975f
C271 a_69317_32762.t0 VSS 0.17182f
C272 a_69317_32762.t1 VSS 0.17182f
C273 a_72757_32984.t0 VSS 0.02101f
C274 a_72757_32984.t1 VSS 0.02101f
C275 a_70530_32714.t0 VSS 0.01097f
C276 a_70530_32714.t1 VSS 0.01097f
C277 a_74957_32984.t0 VSS 0.01976f
C278 a_74957_32984.t1 VSS 0.01976f
C279 a_76557_32392.t0 VSS 0.0373f
C280 a_76557_32392.t1 VSS 0.0373f
C281 a_78030_32132.t0 VSS 0.02611f
C282 a_78030_32132.t1 VSS 0.02611f
C283 a_76557_31872.t0 VSS 0.0311f
C284 a_76557_31872.t1 VSS 0.0311f
C285 a_69255_31864.t0 VSS 0.01856f
C286 a_69255_31864.t1 VSS 0.01856f
C287 a_69855_31748.t1 VSS 0.05458f
C288 a_69855_31748.n0 VSS 0.28038f
C289 a_69855_31748.t2 VSS 0.04466f
C290 a_69855_31748.t3 VSS 0.06817f
C291 a_69855_31748.n1 VSS 0.54239f
C292 a_69855_31748.t0 VSS 0.11213f
C293 a_70517_31292.t0 VSS 0.05397f
C294 a_70517_31292.n0 VSS 0.29299f
C295 a_70517_31292.t3 VSS 0.07228f
C296 a_70517_31292.n1 VSS 0.64789f
C297 a_70517_31292.t2 VSS 0.04454f
C298 a_70517_31292.t1 VSS 0.13091f
C299 a_69255_31678.t1 VSS 0.04366f
C300 a_69255_31678.t0 VSS 0.08869f
C301 a_69255_31678.n0 VSS 0.37321f
C302 a_69255_31678.t2 VSS 0.03098f
C303 a_71355_31864.t0 VSS 0.0212f
C304 a_71355_31864.t1 VSS 0.0212f
C305 a_71955_31748.t1 VSS 0.05798f
C306 a_71955_31748.n0 VSS 0.29785f
C307 a_71955_31748.t2 VSS 0.04744f
C308 a_71955_31748.t3 VSS 0.07242f
C309 a_71955_31748.n1 VSS 0.57618f
C310 a_71955_31748.t0 VSS 0.11911f
C311 a_71355_31678.t1 VSS 0.04523f
C312 a_71355_31678.t0 VSS 0.09188f
C313 a_71355_31678.n0 VSS 0.38663f
C314 a_71355_31678.t2 VSS 0.0321f
C315 a_73225_31738.t0 VSS 0.10001f
C316 a_73225_31738.t1 VSS 0.17278f
C317 a_73225_31738.n0 VSS 0.73323f
C318 a_73225_31738.t2 VSS 0.11841f
C319 a_73225_31738.n1 VSS 1.12878f
C320 a_73225_31738.t4 VSS 0.09878f
C321 a_73225_31738.n2 VSS 0.68428f
C322 a_73225_31738.t5 VSS 0.10334f
C323 a_73225_31738.n3 VSS 1.2323f
C324 a_73225_31738.t3 VSS 0.10829f
C325 a_73893_31864.t0 VSS 0.01912f
C326 a_73893_31864.t1 VSS 0.01912f
C327 a_74493_31748.t0 VSS 0.05146f
C328 a_74493_31748.n0 VSS 0.26437f
C329 a_74493_31748.t2 VSS 0.04211f
C330 a_74493_31748.t3 VSS 0.06428f
C331 a_74493_31748.n1 VSS 0.51143f
C332 a_74493_31748.t1 VSS 0.10572f
C333 a_73893_31678.t0 VSS 0.04433f
C334 a_73893_31678.t1 VSS 0.09004f
C335 a_73893_31678.n0 VSS 0.37889f
C336 a_73893_31678.t2 VSS 0.03145f
C337 DOUBLER_K.t5 VSS 1.39451f
C338 DOUBLER_K.t4 VSS 0.07839f
C339 DOUBLER_K.n0 VSS 0.37971f
C340 VDD.t20 VSS 0.02576f
C341 VDD.t22 VSS 0.01929f
C342 VDD.n0 VSS 0.03962f
C343 VDD.t35 VSS 0.06128f
C344 VDD.n1 VSS 0.04095f
C345 VDD.t19 VSS 0.1597f
C346 VDD.t21 VSS 0.1012f
C347 VDD.t34 VSS 0.24557f
C348 VDD.n2 VSS 0.14302f
C349 VDD.n3 VSS 0.52753f
C350 VDD.t45 VSS 0.0267f
C351 VDD.n4 VSS 0.02487f
C352 VDD.t51 VSS 0.12866f
C353 VDD.t2 VSS 0.12972f
C354 VDD.t3 VSS 0.02713f
C355 VDD.n5 VSS 0.04181f
C356 VDD.n6 VSS 0.10615f
C357 VDD.t44 VSS 0.10589f
C358 VDD.n7 VSS 0.10615f
C359 VDD.n8 VSS 0.03983f
C360 VDD.t52 VSS 0.01929f
C361 VDD.n9 VSS 0.31897f
C362 VDD.n10 VSS 8.55663f
C363 VDD.n11 VSS 0.02618f
C364 VDD.t43 VSS 0.02036f
C365 VDD.t24 VSS 0.01204f
C366 VDD.t7 VSS 0.01305f
C367 VDD.n12 VSS 0.02618f
C368 VDD.n13 VSS 0.0283f
C369 VDD.n14 VSS 0.0283f
C370 VDD.n15 VSS 0.03602f
C371 VDD.t27 VSS 0.0106f
C372 VDD.t38 VSS 0.07081f
C373 VDD.t37 VSS 0.01086f
C374 VDD.n16 VSS 0.02219f
C375 VDD.n17 VSS 0.04419f
C376 VDD.t39 VSS 0.01086f
C377 VDD.t48 VSS 0.0106f
C378 VDD.t13 VSS 0.07016f
C379 VDD.t47 VSS 0.0254f
C380 VDD.t17 VSS 0.23852f
C381 VDD.t18 VSS 0.01084f
C382 VDD.n18 VSS 0.03911f
C383 VDD.n19 VSS 0.07305f
C384 VDD.n20 VSS 0.0998f
C385 VDD.t36 VSS 0.14773f
C386 VDD.n21 VSS 0.15402f
C387 VDD.n22 VSS 0.02178f
C388 VDD.n23 VSS 0.03619f
C389 VDD.n24 VSS 0.01681f
C390 VDD.n25 VSS 0.04419f
C391 VDD.n26 VSS 0.1656f
C392 VDD.t15 VSS 0.07081f
C393 VDD.t14 VSS 0.14206f
C394 VDD.t23 VSS 0.17167f
C395 VDD.t53 VSS 0.09968f
C396 VDD.t42 VSS 0.0692f
C397 VDD.t6 VSS 0.18453f
C398 VDD.n27 VSS 0.16289f
C399 VDD.t41 VSS 0.0106f
C400 VDD.n28 VSS 0.01433f
C401 VDD.t9 VSS 0.01086f
C402 VDD.n29 VSS 0.02219f
C403 VDD.n30 VSS 0.03604f
C404 VDD.t25 VSS 0.01084f
C405 VDD.n31 VSS 0.03911f
C406 VDD.n32 VSS -0.11863f
C407 VDD.t40 VSS 0.11698f
C408 VDD.t10 VSS 0.2562f
C409 VDD.t8 VSS 0.1901f
C410 VDD.t46 VSS 0.07016f
C411 VDD.t30 VSS 0.0254f
C412 VDD.t4 VSS 0.07081f
C413 VDD.t49 VSS 0.07081f
C414 VDD.n34 VSS 0.15101f
C415 VDD.t5 VSS 0.01084f
C416 VDD.n35 VSS 0.0294f
C417 VDD.n36 VSS 0.08867f
C418 VDD.t50 VSS 0.01086f
C419 VDD.t31 VSS 0.0106f
C420 VDD.n37 VSS 0.02178f
C421 VDD.n38 VSS 0.03619f
C422 VDD.n39 VSS 0.01681f
C423 VDD.n40 VSS 0.19607f
C424 VDD.n41 VSS 0.19607f
C425 VDD.t29 VSS 0.0106f
C426 VDD.n42 VSS 0.01433f
C427 VDD.t11 VSS 0.01086f
C428 VDD.n43 VSS 0.02219f
C429 VDD.n44 VSS 0.03601f
C430 VDD.t33 VSS 0.01297f
C431 VDD.n45 VSS 0.04463f
C432 VDD.t1 VSS 0.01084f
C433 VDD.n46 VSS 0.02376f
C434 VDD.n47 VSS 0.02791f
C435 VDD.t12 VSS 0.32029f
C436 VDD.t0 VSS 0.08239f
C437 VDD.t28 VSS 0.14624f
C438 VDD.t32 VSS 0.03953f
C439 VDD.n48 VSS 0.7156f
C440 VDD.n49 VSS 0.14713f
C441 VDD.t16 VSS 0.01084f
C442 VDD.n50 VSS 0.0294f
C443 VDD.n51 VSS 0.07305f
C444 VDD.t26 VSS 0.09162f
C445 VDD.n52 VSS 0.15402f
C446 VDD.n53 VSS 0.01434f
C447 VDD.n54 VSS 0.02856f
C448 VDD.n55 VSS 0.26673f
C449 VDD.n56 VSS 0.11162f
C450 VDD.n57 VSS 0.05576f
C451 VDD.n58 VSS 0.0747f
C452 VDD.n59 VSS 0.07516f
C453 VDD.n60 VSS 0.04336f
C454 VDD.n61 VSS 0.46849f
C455 VDD.n62 VSS 6.66875f
C456 VDD_VCO.t5 VSS 0.08865f
C457 VDD_VCO.t7 VSS 0.0921f
C458 VDD_VCO.t4 VSS 0.52513f
C459 VDD_VCO.t6 VSS 0.52513f
C460 VDD_VCO.n0 VSS 0.4104f
C461 VDD_VCO.n1 VSS 0.10715f
C462 VDD_VCO.n2 VSS 0.13293f
C463 VDD_VCO.t3 VSS 0.08848f
C464 VDD_VCO.t13 VSS 0.089f
C465 VDD_VCO.n3 VSS 0.03847f
C466 VDD_VCO.n4 VSS 0.23903f
C467 VDD_VCO.t2 VSS 0.4547f
C468 VDD_VCO.t12 VSS 0.4547f
C469 VDD_VCO.n5 VSS 0.32868f
C470 VDD_VCO.t10 VSS 0.4547f
C471 VDD_VCO.t14 VSS 0.4547f
C472 VDD_VCO.n6 VSS 0.32065f
C473 VDD_VCO.n7 VSS 0.1026f
C474 VDD_VCO.n8 VSS 0.12082f
C475 VDD_VCO.t11 VSS 0.08891f
C476 VDD_VCO.t15 VSS 0.08852f
C477 VDD_VCO.n9 VSS 0.03853f
C478 VDD_VCO.n10 VSS 0.05974f
C479 VDD_VCO.t9 VSS 0.09212f
C480 VDD_VCO.t8 VSS 0.52513f
C481 VDD_VCO.t0 VSS 0.52513f
C482 VDD_VCO.n11 VSS 0.4104f
C483 VDD_VCO.n12 VSS 0.11485f
C484 VDD_VCO.t1 VSS 0.08846f
C485 VDD_VCO.n13 VSS 0.17885f
C486 VDD_VCO.n14 VSS 0.11996f
C487 CORE_CLK.t2 VSS 0.04212f
C488 CORE_CLK.t6 VSS 0.03514f
C489 CORE_CLK.n0 VSS 0.40294f
C490 CORE_CLK.t7 VSS 0.03676f
C491 CORE_CLK.t4 VSS 0.03852f
C492 CORE_CLK.n1 VSS 0.43964f
C493 CORE_CLK.t5 VSS 0.03118f
C494 CORE_CLK.t9 VSS 0.03676f
C495 CORE_CLK.t3 VSS 0.04212f
C496 CORE_CLK.t8 VSS 0.03514f
C497 CORE_CLK.n2 VSS 0.4589f
C498 CORE_CLK.n3 VSS 0.23442f
C499 CORE_CLK.n4 VSS 0.31727f
C500 CORE_CLK.n5 VSS 0.17699f
C501 CORE_CLK.t10 VSS 0.02947f
C502 CORE_CLK.n6 VSS 0.19237f
C503 CORE_CLK.t11 VSS 0.01652f
C504 CORE_CLK.n7 VSS 0.13398f
C505 CORE_CLK.t12 VSS 0.0244f
C506 CORE_CLK.t1 VSS 0.31155f
C507 CORE_CLK.t0 VSS 0.11933f
C508 CORE_CLK.n8 VSS 3.08665f
C509 O1P.t0 VSS 0.62897f
C510 O1P.t2 VSS 0.29983f
C511 O1P.n0 VSS 0.93356f
C512 O1P.t1 VSS 0.08525f
C513 O1P.t6 VSS 0.04504f
C514 O1P.t5 VSS 0.21173f
C515 O1P.t4 VSS 0.11284f
C516 O1P.n1 VSS 0.99112f
C517 O1P.t8 VSS 0.11644f
C518 O1P.t7 VSS 0.33282f
C519 O1P.n2 VSS 1.27708f
C520 O1P.n3 VSS 0.38628f
C521 O1P.n4 VSS 0.17705f
C522 O1P.n5 VSS 0.21308f
C523 O1P.n6 VSS 0.10695f
C524 O1P.t3 VSS 0.16051f
C525 VTUNE.t7 VSS 0.04575f
C526 VTUNE.t6 VSS 0.06417f
C527 VTUNE.t5 VSS 0.06596f
C528 VTUNE.t4 VSS 0.06417f
C529 VTUNE.n0 VSS 0.16121f
C530 VTUNE.t3 VSS 0.06417f
C531 VTUNE.n1 VSS 0.09791f
C532 VTUNE.t0 VSS 0.06417f
C533 VTUNE.n2 VSS 0.23666f
C534 VTUNE.t2 VSS 0.07095f
C535 VTUNE.t1 VSS 0.06417f
C536 VTUNE.n3 VSS 0.57736f
C537 VTUNE.n4 VSS 0.39428f
C538 VTUNE.n5 VSS 0.06583f
C539 O1N.t5 VSS 0.04805f
C540 O1N.t2 VSS 0.15134f
C541 O1N.t1 VSS 0.27439f
C542 O1N.t6 VSS 0.16188f
C543 O1N.t4 VSS 0.21418f
C544 O1N.n0 VSS 1.70939f
C545 O1N.n1 VSS 0.25689f
C546 O1N.n2 VSS 0.1949f
C547 O1N.n3 VSS 0.27052f
C548 O1N.t0 VSS 0.38124f
C549 O1N.t7 VSS 0.29313f
C550 O1N.n4 VSS 0.80889f
C551 O1N.t8 VSS 0.17413f
C552 O1N.n5 VSS 1.05288f
C553 O1N.t3 VSS 0.07366f
C554 O1N.n6 VSS 0.10741f
C555 TAIL_BIAS.t0 VSS 0.04139f
C556 MC.t0 VSS 0.31162f
C557 MIM_TOP.t0 VSS 0.01315f
C558 MIM_TOP.t3 VSS 0.01236f
C559 MIM_TOP.n0 VSS 0.03924f
C560 MIM_TOP.t1 VSS 1.46522f
C561 MIM_TOP.n1 VSS 0.06576f
C562 PRESCALED.t3 VSS 0.01067f
C563 PRESCALED.t2 VSS 0.01412f
C564 PRESCALED.n0 VSS 0.0935f
C565 PRESCALED.t0 VSS 0.02665f
C566 PRESCALED.t1 VSS 0.01115f
C567 PRESCALED.t4 VSS 0.0106f
C568 PRESCALED.n1 VSS 0.14856f
C569 PRESCALED.n2 VSS 2.87994f
C570 RF_OUT.t1 VSS 0.09003f
C571 RF_OUT.t0 VSS 0.04219f
C572 RF_OUT.n0 VSS 0.15095f
C573 O3P.t4 VSS 0.0587f
C574 O3P.t2 VSS 0.11362f
C575 O3P.t0 VSS 0.05682f
C576 O3P.t5 VSS 0.03608f
C577 O3P.n0 VSS 0.25171f
C578 O3P.n1 VSS 0.13252f
C579 O3P.t1 VSS 0.2051f
C580 O3P.n2 VSS 0.30814f
C581 O3P.t3 VSS 0.2054f
C582 O3P.n3 VSS 0.17115f
C583 O3P.t6 VSS 0.11541f
C584 O3P.n4 VSS 0.9195f
C585 O4N.t4 VSS 0.15731f
C586 O4N.t6 VSS 0.1006f
C587 O4N.n0 VSS 1.35053f
C588 O4N.t3 VSS 0.25548f
C589 O4N.n1 VSS 0.34614f
C590 O4N.t2 VSS 0.07264f
C591 O4N.t0 VSS 0.19871f
C592 O4N.t5 VSS 0.03845f
C593 O4N.n2 VSS 0.3808f
C594 O4N.n3 VSS 0.17849f
C595 O4N.n4 VSS 0.09113f
C596 O4N.t1 VSS 0.13677f
C597 O2P.t6 VSS 0.09263f
C598 O2P.t5 VSS 0.17735f
C599 O2P.t3 VSS 0.17929f
C600 O2P.t0 VSS 0.08966f
C601 O2P.t4 VSS 0.05693f
C602 O2P.n0 VSS 0.39718f
C603 O2P.n1 VSS 0.20884f
C604 O2P.t1 VSS 0.28042f
C605 O2P.n2 VSS 0.43257f
C606 O2P.t2 VSS 0.32378f
C607 O2P.n3 VSS 0.28973f
C608 O2P.n4 VSS 0.98301f
C609 O3N.t1 VSS 0.14402f
C610 O3N.t3 VSS 0.07649f
C611 O3N.t6 VSS 0.04686f
C612 O3N.n0 VSS 0.31026f
C613 O3N.t2 VSS 0.23602f
C614 O3N.t0 VSS 0.26902f
C615 O3N.n1 VSS 0.51366f
C616 O3N.t4 VSS 0.18284f
C617 O3N.t5 VSS 0.14269f
C618 O3N.n2 VSS 1.08949f
C619 O3N.n3 VSS 0.16764f
C620 O3N.n4 VSS 0.08424f
C621 O4P.t6 VSS 0.10525f
C622 O4P.t5 VSS 0.16941f
C623 O4P.n0 VSS 0.847f
C624 O4P.t4 VSS 0.04797f
C625 O4P.n1 VSS 0.20559f
C626 O4P.t3 VSS 0.18128f
C627 O4P.t0 VSS 0.37571f
C628 O4P.t2 VSS 0.27771f
C629 O4P.n2 VSS 0.75537f
C630 O4P.n3 VSS 0.20695f
C631 O4P.n4 VSS 0.1477f
C632 O4P.t1 VSS 0.08837f
C633 O2N.t2 VSS 0.11388f
C634 O2N.t3 VSS 0.06048f
C635 O2N.t6 VSS 0.07466f
C636 O2N.t4 VSS 0.17043f
C637 O2N.n0 VSS 0.97391f
C638 O2N.t5 VSS 0.03195f
C639 O2N.n1 VSS 0.12525f
C640 O2N.n2 VSS 0.15118f
C641 O2N.t1 VSS 0.20008f
C642 O2N.t0 VSS 0.24706f
C643 O2N.n3 VSS 0.53653f
C644 O2N.n4 VSS 0.05503f
RTAP1 a_76968_33670.n1 RF_OUT 1m
.ends
