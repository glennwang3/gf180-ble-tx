* NGSPICE file created from RF_PART.ext - technology: gf180mcuE

.subckt RF_PART D1 VTUNE DOUBLER_K MIM_TOP O1P O1N O2N O3N O4N O4P O2P O3P RF_DRV1
+ VCTRL MC PA_DRAIN VDD VSS VDD_VCO CORE_CLK PRESCALED TAIL_BIAS CP_IBIAS
X0 a_n4939_1760.t1 MIM_TOP.t0 VSS.t16 ppolyf_u r_width=0.8u r_length=6.705u
X1 TAIL_BIAS.t5 VSS.t185 cap_nmos_03v3 c_width=20u c_length=6u
X2 a_280_7194.t1 CORE_CLK.t5 VDD.t101 VDD.t100 pfet_03v3 ad=0.728p pd=3.54u as=0.728p ps=3.54u w=1.12u l=0.28u
X3 VDD.t54 a_3032_n194.t53 VDD_VCO.t17 VDD.t53 pfet_03v3 ad=1.04p pd=4.52u as=1.04p ps=4.52u w=4u l=0.28u
X4 a_9736_n12398.t1 a_13712_n12918.t1 VSS.t3 ppolyf_u_1k r_width=1u r_length=19.24u
X5 a_n1758_7844.t1 a_n2420_7264.t2 a_n1820_7194.t1 VSS.t61 nfet_03v3 ad=0.1456p pd=1.08u as=0.3416p ps=2.34u w=0.56u l=0.28u
X6 VDD_VCO.t16 a_3032_n194.t40 VDD.t48 VDD.t47 pfet_03v3 ad=1.04p pd=4.52u as=1.04p ps=4.52u w=4u l=0.28u
X7 a_n9960_n5954.t2 a_n8920_n7666.t0 VSS.t5 ppolyf_u_1k r_width=1u r_length=4.68u
X8 VSS.t124 D1.t24 PA_DRAIN.t9 VSS.t123 nfet_03v3 ad=0.8125p pd=3.645u as=0.8125p ps=3.645u w=3.125u l=0.28u
X9 VDD_VCO.t66 VSS.t183 cap_nmos_03v3 c_width=10u c_length=6u
X10 a_342_7844.t0 a_n320_7264.t2 a_280_7194.t0 VSS.t21 nfet_03v3 ad=0.1456p pd=1.08u as=0.3416p ps=2.34u w=0.56u l=0.28u
X11 VSS.t102 a_13714_n17054.t6 a_9736_n9958.t4 VSS.t101 nfet_03v3 ad=3.66p pd=13.22u as=1.56p ps=6.52u w=6u l=1.5u
X12 a_15736_n9878.t0 a_18870_n10398.t1 VSS.t48 ppolyf_u_1k r_width=1u r_length=15.03u
X13 a_2818_7194.t1 a_1550_7204.t2 VDD.t105 VDD.t104 pfet_03v3 ad=0.728p pd=3.54u as=0.728p ps=3.54u w=1.12u l=0.28u
X14 VDD.t195 a_3032_n194.t37 VDD_VCO.t53 VDD.t194 pfet_03v3 ad=1.04p pd=4.52u as=1.04p ps=4.52u w=4u l=0.28u
X15 a_n9960_n4694.t1 a_n9960_n3176.t4 VSS.t34 VSS.t33 nfet_03v3 ad=0.52p pd=2.52u as=1.22p ps=5.22u w=2u l=0.28u
X16 VSS.t20 a_n9960_n4694.t10 a_n9960_n5954.t5 VSS.t19 nfet_03v3 ad=1.42435p pd=5.89u as=0.6071p ps=2.855u w=2.335u l=0.28u
X17 VSS.t201 a_n8920_n7666.t11 D1.t13 VSS.t200 nfet_03v3 ad=0.7436p pd=3.38u as=1.7446p ps=6.94u w=2.86u l=0.28u
X18 CP_IBIAS.t0 a_22018_6314.t4 a_24874_6374.t0 VDD.t153 pfet_03v3 ad=0.676p pd=3.38u as=0.676p ps=3.38u w=1.04u l=5u
X19 a_9934_n17054.t5 a_3336_n8238.t3 a_13714_n17054.t1 VDD.t130 pfet_03v3 ad=3.9p pd=13.3u as=1.56p ps=6.52u w=6u l=1.5u
X20 a_n1630_5384.t0 CORE_CLK.t2 VSS.t66 VSS.t65 nfet_03v3 ad=93.59999f pd=0.88u as=0.228p ps=1.98u w=0.36u l=0.36u
X21 PA_DRAIN.t0 D1.t17 VSS.t138 VSS.t137 nfet_03v3 ad=0.8125p pd=3.645u as=0.8125p ps=3.645u w=3.125u l=0.28u
X22 D1.t2 a_n8920_n7666.t14 VDD.t121 VDD.t120 pfet_03v3 ad=1.3p pd=5.52u as=1.3p ps=5.52u w=5u l=0.28u
X23 a_n320_7264.t1 CORE_CLK.t7 a_n320_7104.t0 VDD.t95 pfet_03v3 ad=0.728p pd=3.54u as=0.2912p ps=1.64u w=1.12u l=0.28u
X24 VDD.t109 a_3032_n194.t23 VDD_VCO.t32 VDD.t108 pfet_03v3 ad=1.04p pd=4.52u as=1.04p ps=4.52u w=4u l=0.28u
X25 VDD.t134 a_3032_n194.t9 VDD_VCO.t39 VDD.t133 pfet_03v3 ad=1.04p pd=4.52u as=1.04p ps=4.52u w=4u l=0.28u
X26 a_3032_n194.t1 a_9736_n9958.t7 VSS.t38 VSS.t37 nfet_03v3 ad=2.08p pd=8.52u as=4.88p ps=17.22u w=8u l=0.6u
X27 a_9736_n10398.t1 a_10742_n10398.t1 VSS.t192 ppolyf_u_1k r_width=1u r_length=4.39u
X28 VDD_VCO.t30 O4P.t5 O2P.t2 VDD_VCO.t29 pfet_03v3 ad=1.95p pd=7.3u as=1.95p ps=7.3u w=3u l=0.28u
X29 VDD.t69 a_n11000_n1140.t5 a_n9960_n3176.t0 VDD.t68 pfet_03v3 ad=3.25p pd=11.3u as=3.25p ps=11.3u w=5u l=0.28u
X30 VDD.t3 a_n9960_n4694.t7 a_n9960_n5954.t0 VDD.t2 pfet_03v3 ad=1.2129p pd=5.185u as=3.03225p ps=10.63u w=4.665u l=0.28u
X31 a_15736_n12398.t1 a_19812_n12918.t1 VSS.t13 ppolyf_u_1k r_width=1u r_length=19.74u
X32 VDD.t159 a_1922_5998.t3 a_n1170_5156.t1 VDD.t158 pfet_03v3 ad=0.728p pd=3.54u as=0.728p ps=3.54u w=1.12u l=0.28u
X33 VDD.t91 a_n2218_3378.t3 CORE_CLK.t0 VDD.t90 pfet_03v3 ad=2.6p pd=9.3u as=2.6p ps=9.3u w=4u l=0.28u
X34 VSS.t116 D1.t28 PA_DRAIN.t13 VSS.t115 nfet_03v3 ad=0.8125p pd=3.645u as=0.8125p ps=3.645u w=3.125u l=0.28u
X35 a_n1110_5556.t0 CORE_CLK.t3 a_n1110_5388.t0 VSS.t4 nfet_03v3 ad=93.59999f pd=0.88u as=93.59999f ps=0.88u w=0.36u l=0.32u
X36 VSS.t147 O4N.t6 O1P.t1 VSS.t146 nfet_03v3 ad=0.915p pd=4.22u as=0.915p ps=4.22u w=1.5u l=0.28u
X37 a_9736_n12398.t0 a_13712_n11878.t1 VSS.t3 ppolyf_u_1k r_width=1u r_length=19.24u
X38 a_2218_7264.t0 a_1550_7204.t3 a_2218_7104.t0 VDD.t41 pfet_03v3 ad=0.728p pd=3.54u as=0.2912p ps=1.64u w=1.12u l=0.28u
X39 a_n8920_n7666.t1 a_n9960_n5954.t10 VDD.t38 VDD.t37 pfet_03v3 ad=1.248p pd=5.32u as=1.248p ps=5.32u w=4.8u l=0.28u
X40 a_13714_n17054.t0 a_3336_n8238.t4 a_9934_n17054.t0 VDD.t42 pfet_03v3 ad=1.56p pd=6.52u as=3.9p ps=13.3u w=6u l=1.5u
X41 VDD.t169 a_3032_n194.t29 VDD_VCO.t43 VDD.t168 pfet_03v3 ad=1.04p pd=4.52u as=1.04p ps=4.52u w=4u l=0.28u
X42 a_n2358_6180.t0 a_n2588_5202.t4 a_n2556_7038.t2 VDD.t67 pfet_03v3 ad=0.728p pd=3.54u as=0.728p ps=3.54u w=1.12u l=0.28u
X43 a_n866_2740.t1 TAIL_BIAS.t6 VSS.t191 VSS.t190 nfet_03v3 ad=0.61p pd=3.22u as=0.61p ps=3.22u w=1u l=0.28u
X44 a_n4939_n460.t0 a_n3466_n200.t1 VSS.t166 ppolyf_u r_width=0.8u r_length=6.705u
X45 a_3032_n194.t4 a_11150_n9958.t0 cap_mim_2f0_m5m6_noshield c_width=28.7u c_length=87u
X46 VSS.t149 a_n8920_n7666.t19 D1.t7 VSS.t148 nfet_03v3 ad=0.7436p pd=3.38u as=0.7436p ps=3.38u w=2.86u l=0.28u
X47 a_n2556_7038.t0 a_n2418_6310.t2 VSS.t79 VSS.t78 nfet_03v3 ad=0.3416p pd=2.34u as=0.3416p ps=2.34u w=0.56u l=0.28u
X48 TAIL_BIAS.t2 TAIL_BIAS.t1 VSS.t189 VSS.t188 nfet_03v3 ad=0.61p pd=3.22u as=0.61p ps=3.22u w=1u l=5.6u
X49 a_3032_n194.t5 a_11150_n9958.t2 cap_mim_2f0_m5m6_noshield c_width=28.7u c_length=87u
X50 a_3336_n11358.t0 a_4728_n11878.t1 VSS.t7 ppolyf_u_1k r_width=1u r_length=6.32u
X51 PA_DRAIN.t4 D1.t21 VSS.t130 VSS.t129 nfet_03v3 ad=0.8125p pd=3.645u as=0.8125p ps=3.645u w=3.125u l=0.28u
X52 RF_DRV1.t2 MIM_TOP.t2 VSS.t110 VSS.t109 nfet_03v3 ad=0.61p pd=3.22u as=0.61p ps=3.22u w=1u l=0.28u
D0 O1P.t7 DOUBLER_K sc_diode pj=3.24u area=0.62p
X53 VDD_VCO.t57 O2P.t5 O4N.t2 VDD_VCO.t56 pfet_03v3 ad=1.95p pd=7.3u as=1.95p ps=7.3u w=3u l=0.28u
X54 VDD_VCO.t20 a_3032_n194.t26 VDD.t73 VDD.t72 pfet_03v3 ad=1.04p pd=4.52u as=1.04p ps=4.52u w=4u l=0.28u
X55 a_3336_n8238.t1 a_18870_n10398.t0 VSS.t48 ppolyf_u_1k r_width=1u r_length=15.03u
X56 PRESCALED.t1 a_n1170_5156.t5 a_n68_5252.t1 VSS.t221 nfet_03v3 ad=0.3416p pd=2.34u as=0.1456p ps=1.08u w=0.56u l=0.28u
X57 VDD_VCO.t26 a_3032_n194.t48 VDD.t83 VDD.t82 pfet_03v3 ad=1.04p pd=4.52u as=1.04p ps=4.52u w=4u l=0.28u
X58 VDD.t71 a_3032_n194.t35 VDD_VCO.t19 VDD.t70 pfet_03v3 ad=1.04p pd=4.52u as=1.04p ps=4.52u w=4u l=0.28u
X59 PA_DRAIN.t10 D1.t25 VSS.t122 VSS.t121 nfet_03v3 ad=0.8125p pd=3.645u as=0.8125p ps=3.645u w=3.125u l=0.28u
X60 a_3336_n10318.t0 a_4728_n9798.t0 VSS.t7 ppolyf_u_1k r_width=1u r_length=6.32u
X61 VDD_VCO.t81 VSS.t168 cap_nmos_03v3 c_width=10u c_length=6u
X62 VDD_VCO.t75 VSS.t174 cap_nmos_03v3 c_width=10u c_length=6u
X63 VDD_VCO.t69 VSS.t180 cap_nmos_03v3 c_width=10u c_length=6u
X64 a_9934_n17054.t3 a_17294_n17114.t2 a_9736_n9958.t1 VDD.t78 pfet_03v3 ad=3.9p pd=13.3u as=1.56p ps=6.52u w=6u l=1.5u
X65 VSS.t18 a_1550_7204.t5 a_2880_7844.t0 VSS.t17 nfet_03v3 ad=0.3416p pd=2.34u as=0.1456p ps=1.08u w=0.56u l=0.28u
X66 a_n4939_2280.t0 RF_DRV1.t1 VSS.t16 ppolyf_u r_width=0.8u r_length=6.705u
X67 O3N.t2 O3P.t5 VSS.t157 VSS.t156 nfet_03v3 ad=0.4697p pd=2.76u as=0.4697p ps=2.76u w=0.77u l=0.28u
X68 VSS.t56 a_n9960_n3176.t6 a_n9960_n4694.t4 VSS.t55 nfet_03v3 ad=1.22p pd=5.22u as=0.52p ps=2.52u w=2u l=0.28u
X69 a_9934_n17054.t2 a_2982_n17114.t4 VDD.t66 VDD.t65 pfet_03v3 ad=2.08p pd=8.52u as=5.2p ps=17.3u w=8u l=1u
X70 a_15736_n12398.t0 a_19812_n11878.t0 VSS.t13 ppolyf_u_1k r_width=1u r_length=19.74u
X71 a_472_5348.t1 PRESCALED.t3 VSS.t159 VSS.t158 nfet_03v3 ad=0.3416p pd=2.34u as=0.3416p ps=2.34u w=0.56u l=0.28u
X72 VDD_VCO.t37 a_3032_n194.t32 VDD.t129 VDD.t128 pfet_03v3 ad=1.04p pd=4.52u as=1.04p ps=4.52u w=4u l=0.28u
X73 a_15736_n9878.t1 VSS.t199 VSS.t48 ppolyf_u_1k r_width=1u r_length=15.03u
X74 D1.t1 a_n8920_n7666.t13 VSS.t83 VSS.t82 nfet_03v3 ad=0.7436p pd=3.38u as=0.7436p ps=3.38u w=2.86u l=0.28u
X75 a_n2556_7038.t1 a_n2588_5202.t2 VSS.t198 VSS.t197 nfet_03v3 ad=0.3416p pd=2.34u as=0.3416p ps=2.34u w=0.56u l=0.28u
X76 a_2132_5252.t1 a_1922_5998.t2 VSS.t143 VSS.t31 nfet_03v3 ad=0.1456p pd=1.08u as=0.3416p ps=2.34u w=0.56u l=0.28u
X77 VDD_VCO.t3 a_3032_n194.t54 VDD.t9 VDD.t8 pfet_03v3 ad=1.04p pd=4.52u as=2.6p ps=9.3u w=4u l=0.28u
X78 PA_DRAIN.t14 D1.t29 VSS.t114 VSS.t113 nfet_03v3 ad=0.8125p pd=3.645u as=0.8125p ps=3.645u w=3.125u l=0.28u
X79 VSS.t136 D1.t18 PA_DRAIN.t1 VSS.t135 nfet_03v3 ad=0.8125p pd=3.645u as=0.8125p ps=3.645u w=3.125u l=0.28u
X80 VDD.t190 a_n12040_766.t5 a_n11000_n1140.t2 VDD.t189 pfet_03v3 ad=2.08p pd=7.7u as=2.08p ps=7.7u w=3.2u l=0.28u
X81 O2N.t2 O1N.t4 VSS.t41 VSS.t40 nfet_03v3 ad=0.915p pd=4.22u as=0.915p ps=4.22u w=1.5u l=0.28u
X82 a_n12040_1968.t0 a_n11520_766.t1 VSS.t8 ppolyf_u_1k r_width=1u r_length=5.37u
X83 a_n11000_1968.t0 a_n11520_766.t0 VSS.t8 ppolyf_u_1k r_width=1u r_length=5.37u
X84 VTUNE.t2 O4N.t0 cap_nmos_03v3 c_width=1u c_length=1u
X85 a_n8920_n7666.t5 a_n9960_n5954.t13 VSS.t98 VSS.t97 nfet_03v3 ad=0.78p pd=3.52u as=0.78p ps=3.52u w=3u l=0.28u
X86 VSS.t81 a_13714_n17054.t4 a_13714_n17054.t5 VSS.t80 nfet_03v3 ad=3.66p pd=13.22u as=1.56p ps=6.52u w=6u l=1.5u
X87 a_n11000_1968.t1 a_n10480_766.t1 VSS.t8 ppolyf_u_1k r_width=1u r_length=5.37u
X88 VDD.t210 a_3032_n194.t51 VDD_VCO.t58 VDD.t209 pfet_03v3 ad=1.04p pd=4.52u as=1.04p ps=4.52u w=4u l=0.28u
X89 a_3336_n11358.t1 a_4728_n10838.t0 VSS.t7 ppolyf_u_1k r_width=1u r_length=6.32u
X90 a_n1110_5388.t1 a_n1170_5324.t4 a_n1110_5220.t1 VSS.t4 nfet_03v3 ad=93.59999f pd=0.88u as=93.59999f ps=0.88u w=0.36u l=0.32u
X91 VTUNE.t7 O1P.t3 cap_nmos_03v3 c_width=1u c_length=1u
X92 a_9736_n9958.t0 a_17294_n17114.t3 a_9934_n17054.t1 VDD.t64 pfet_03v3 ad=1.56p pd=6.52u as=3.9p ps=13.3u w=6u l=1.5u
X93 VDD.t40 a_n9960_n5954.t12 a_n8920_n7666.t3 VDD.t39 pfet_03v3 ad=1.248p pd=5.32u as=1.248p ps=5.32u w=4.8u l=0.28u
X94 VDD_VCO.t78 VSS.t171 cap_nmos_03v3 c_width=10u c_length=6u
X95 a_9736_n11358.t0 a_13712_n11878.t0 VSS.t3 ppolyf_u_1k r_width=1u r_length=19.24u
X96 VDD.t137 a_n1134_3368.t1 a_n1134_3368.t2 VDD.t136 pfet_03v3 ad=1.3p pd=5.3u as=1.3p ps=5.3u w=2u l=0.28u
X97 VDD_VCO.t38 a_3032_n194.t10 VDD.t132 VDD.t131 pfet_03v3 ad=1.04p pd=4.52u as=1.04p ps=4.52u w=4u l=0.28u
X98 a_21936_n12398.t1 a_25264_n12918.t1 VSS.t32 ppolyf_u_1k r_width=1u r_length=16u
X99 a_9736_n9958.t2 a_11150_n9958.t3 VSS.t108 ppolyf_u_1k r_width=1u r_length=6.43u
X100 VSS.t26 a_n1158_7658.t3 a_n320_7264.t0 VSS.t25 nfet_03v3 ad=0.3416p pd=2.34u as=0.3416p ps=2.34u w=0.56u l=0.28u
X101 a_n9960_118.t1 a_n9440_n1140.t1 VSS.t6 ppolyf_u_1k r_width=1u r_length=5.65u
X102 a_13714_n17054.t3 a_13714_n17054.t2 VSS.t107 VSS.t106 nfet_03v3 ad=1.56p pd=6.52u as=3.66p ps=13.22u w=6u l=1.5u
X103 a_22272_10590.t1 a_26120_10070.t1 VSS.t2 ppolyf_u_1k r_width=1u r_length=18.6u
X104 a_n2588_5202.t1 a_280_7194.t2 VDD.t206 VDD.t100 pfet_03v3 ad=0.728p pd=3.54u as=0.728p ps=3.54u w=1.12u l=0.28u
X105 VDD_VCO.t71 VSS.t178 cap_nmos_03v3 c_width=10u c_length=6u
X106 VSS.t36 a_9736_n9958.t6 a_3032_n194.t2 VSS.t35 nfet_03v3 ad=2.08p pd=8.52u as=2.08p ps=8.52u w=8u l=0.6u
X107 VDD.t173 a_3032_n194.t21 VDD_VCO.t47 VDD.t172 pfet_03v3 ad=1.04p pd=4.52u as=1.04p ps=4.52u w=4u l=0.28u
X108 VDD.t17 a_3032_n194.t7 VDD_VCO.t7 VDD.t16 pfet_03v3 ad=2.6p pd=9.3u as=1.04p ps=4.52u w=4u l=0.28u
X109 a_22272_9550.t0 a_26120_9030.t0 VSS.t2 ppolyf_u_1k r_width=1u r_length=18.6u
X110 VDD.t175 PRESCALED.t4 a_1082_5984.t1 VDD.t174 pfet_03v3 ad=0.728p pd=3.54u as=0.2912p ps=1.64u w=1.12u l=0.28u
X111 a_3336_n9278.t0 a_4728_n9798.t1 VSS.t7 ppolyf_u_1k r_width=1u r_length=6.32u
X112 O3N.t3 O1P.t5 VDD_VCO.t61 VDD_VCO.t60 pfet_03v3 ad=1.95p pd=7.3u as=1.95p ps=7.3u w=3u l=0.28u
X113 a_n9960_n1788.t0 a_n9440_n3176.t0 VSS.t73 ppolyf_u_1k r_width=1u r_length=6.3u
X114 a_9736_n9958.t3 a_13714_n17054.t7 VSS.t104 VSS.t103 nfet_03v3 ad=1.56p pd=6.52u as=3.66p ps=13.22u w=6u l=1.5u
X115 PA_DRAIN.t6 D1.t15 VSS.t142 VSS.t141 nfet_03v3 ad=0.8125p pd=3.645u as=1.90625p ps=7.47u w=3.125u l=0.28u
X116 a_1922_5998.t0 a_2672_5348.t2 a_2732_5244.t1 VSS.t161 nfet_03v3 ad=0.3416p pd=2.34u as=0.1456p ps=1.08u w=0.56u l=0.28u
X117 a_n12040_766.t0 a_n9440_n1140.t0 VSS.t6 ppolyf_u_1k r_width=1u r_length=5.65u
X118 VDD_VCO.t18 a_3032_n194.t18 VDD.t60 VDD.t59 pfet_03v3 ad=1.04p pd=4.52u as=1.04p ps=4.52u w=4u l=0.28u
X119 a_n4939_1760.t0 a_n3466_2020.t0 VSS.t16 ppolyf_u r_width=0.8u r_length=6.705u
X120 VSS.t77 RF_DRV1.t4 a_n12040_766.t1 VSS.t76 nfet_03v3 ad=0.61p pd=3.22u as=0.61p ps=3.22u w=1u l=0.28u
X121 a_n9960_118.t0 a_n10480_n1140.t0 VSS.t6 ppolyf_u_1k r_width=1u r_length=5.65u
X122 a_9736_n10398.t0 VCTRL.t0 a_9124_n19574.t0 VSS.t67 nfet_03v3 ad=4.88p pd=17.22u as=4.88p ps=17.22u w=8u l=1u
X123 a_15736_n11358.t1 a_19812_n11878.t1 VSS.t13 ppolyf_u_1k r_width=1u r_length=19.74u
X124 VSS.t47 a_2818_7194.t3 a_3480_7836.t1 VSS.t44 nfet_03v3 ad=0.3416p pd=2.34u as=0.1456p ps=1.08u w=0.56u l=0.28u
X125 a_21936_n10918.t0 VSS.t46 VSS.t32 ppolyf_u_1k r_width=1u r_length=16u
X126 VSS.t112 D1.t30 PA_DRAIN.t15 VSS.t111 nfet_03v3 ad=1.90625p pd=7.47u as=0.8125p ps=3.645u w=3.125u l=0.28u
X127 VSS.t30 a_n1820_7194.t3 a_n1158_7836.t0 VSS.t29 nfet_03v3 ad=0.3416p pd=2.34u as=0.1456p ps=1.08u w=0.56u l=0.28u
X128 a_n2420_7264.t0 CORE_CLK.t8 a_n2420_7104.t1 VDD.t94 pfet_03v3 ad=0.728p pd=3.54u as=0.2912p ps=1.64u w=1.12u l=0.28u
X129 VDD.t23 a_3032_n194.t27 VDD_VCO.t10 VDD.t22 pfet_03v3 ad=1.04p pd=4.52u as=1.04p ps=4.52u w=4u l=0.28u
X130 a_9736_n11358.t1 a_2920_n19634.t0 VSS.t3 ppolyf_u_1k r_width=1u r_length=19.24u
X131 a_n278_5998.t1 a_472_5348.t2 a_532_5244.t0 VSS.t70 nfet_03v3 ad=0.3416p pd=2.34u as=0.1456p ps=1.08u w=0.56u l=0.28u
X132 a_n1110_4884.t1 MC.t0 VSS.t204 VSS.t4 nfet_03v3 ad=93.59999f pd=0.88u as=0.228p ps=1.98u w=0.36u l=0.32u
X133 VSS.t100 a_n9960_n5954.t15 a_n8920_n7666.t7 VSS.t99 nfet_03v3 ad=1.83p pd=7.22u as=0.78p ps=3.52u w=3u l=0.28u
X134 D1.t10 a_n8920_n7666.t22 VDD.t167 VDD.t166 pfet_03v3 ad=1.3p pd=5.52u as=1.3p ps=5.52u w=5u l=0.28u
X135 a_n11000_n1140.t1 a_n9440_n3176.t1 VSS.t73 ppolyf_u_1k r_width=1u r_length=6.3u
X136 a_21936_n12398.t0 a_17294_n17114.t0 VSS.t32 ppolyf_u_1k r_width=1u r_length=16u
X137 TAIL_BIAS.t3 VSS.t187 cap_nmos_03v3 c_width=20u c_length=6u
X138 VDD_VCO.t55 a_3032_n194.t24 VDD.t205 VDD.t204 pfet_03v3 ad=1.04p pd=4.52u as=1.04p ps=4.52u w=4u l=0.28u
X139 a_n9960_n1788.t1 a_n9960_n3176.t2 VSS.t73 ppolyf_u_1k r_width=1u r_length=6.3u
X140 a_3336_n10318.t1 a_4728_n10838.t1 VSS.t7 ppolyf_u_1k r_width=1u r_length=6.32u
X141 a_1550_7204.t0 a_n2588_5202.t6 VDD.t28 VDD.t27 pfet_03v3 ad=0.728p pd=3.54u as=0.728p ps=3.54u w=1.12u l=0.28u
X142 O3N.t1 O2N.t6 VSS.t91 VSS.t90 nfet_03v3 ad=0.915p pd=4.22u as=0.915p ps=4.22u w=1.5u l=0.28u
X143 VDD_VCO.t4 a_3032_n194.t46 VDD.t11 VDD.t10 pfet_03v3 ad=1.04p pd=4.52u as=1.04p ps=4.52u w=4u l=0.28u
X144 a_3032_n194.t6 a_11150_n9958.t1 cap_mim_2f0_m5m6_noshield c_width=28.7u c_length=87u
X145 MIM_TOP.t1 DOUBLER_K.t3 cap_mim_2f0_m5m6_noshield c_width=5u c_length=5u
X146 VDD.t140 a_n1134_3368.t3 a_n2218_3378.t0 VDD.t139 pfet_03v3 ad=1.3p pd=5.3u as=1.3p ps=5.3u w=2u l=0.28u
X147 a_n1145_6254.t1 a_n2588_5202.t5 a_n1690_5488.t0 VDD.t191 pfet_03v3 ad=0.1872p pd=1.24u as=0.468p ps=2.74u w=0.72u l=0.32u
X148 a_1082_5984.t0 a_n1170_5156.t6 a_472_5348.t0 VDD.t26 pfet_03v3 ad=0.2912p pd=1.64u as=0.728p ps=3.54u w=1.12u l=0.28u
X149 a_n4939_n460.t1 VSS.t194 VSS.t193 ppolyf_u r_width=0.8u r_length=6.705u
X150 VDD.t25 a_3032_n194.t43 VDD_VCO.t11 VDD.t24 pfet_03v3 ad=1.04p pd=4.52u as=1.04p ps=4.52u w=4u l=0.28u
X151 a_3336_n9278.t1 a_4728_n8758.t1 VSS.t7 ppolyf_u_1k r_width=1u r_length=6.32u
X152 a_n9960_1968.t1 a_n10480_766.t0 VSS.t8 ppolyf_u_1k r_width=1u r_length=5.37u
X153 O1N.t2 O4P.t6 VSS.t58 VSS.t57 nfet_03v3 ad=0.915p pd=4.22u as=0.915p ps=4.22u w=1.5u l=0.28u
X154 VSS.t214 O1P.t4 O2P.t1 VSS.t213 nfet_03v3 ad=0.915p pd=4.22u as=0.915p ps=4.22u w=1.5u l=0.28u
X155 VDD_VCO.t62 a_3032_n194.t30 VDD.t214 VDD.t213 pfet_03v3 ad=1.04p pd=4.52u as=1.04p ps=4.52u w=4u l=0.28u
X156 a_3032_n194.t3 a_9736_n9958.t5 VSS.t50 VSS.t49 nfet_03v3 ad=4.88p pd=17.22u as=2.08p ps=8.52u w=8u l=0.6u
X157 VDD.t119 a_2982_n17114.t3 a_9934_n17054.t4 VDD.t118 pfet_03v3 ad=5.2p pd=17.3u as=2.08p ps=8.52u w=8u l=1u
X158 a_n9960_1968.t0 a_n9440_766.t0 VSS.t8 ppolyf_u_1k r_width=1u r_length=5.37u
X159 VDD_VCO.t34 a_3032_n194.t52 VDD.t127 VDD.t126 pfet_03v3 ad=1.04p pd=4.52u as=1.04p ps=4.52u w=4u l=0.28u
X160 a_15736_n11358.t0 a_3336_n8238.t0 VSS.t13 ppolyf_u_1k r_width=1u r_length=19.74u
X161 VDD.t123 a_n8920_n7666.t16 D1.t4 VDD.t122 pfet_03v3 ad=1.3p pd=5.52u as=1.3p ps=5.52u w=5u l=0.28u
X162 a_22272_9550.t1 a_26120_10070.t0 VSS.t2 ppolyf_u_1k r_width=1u r_length=18.6u
X163 a_n320_7104.t1 a_n1158_7658.t2 VDD.t179 VDD.t178 pfet_03v3 ad=0.2912p pd=1.64u as=0.728p ps=3.54u w=1.12u l=0.28u
X164 CORE_CLK.t1 a_n2218_3378.t2 VSS.t96 VSS.t95 nfet_03v3 ad=1.22p pd=5.22u as=1.22p ps=5.22u w=2u l=0.28u
X165 VTUNE.t0 O2N.t0 cap_nmos_03v3 c_width=1u c_length=1u
X166 VDD_VCO.t80 VSS.t169 cap_nmos_03v3 c_width=10u c_length=6u
X167 VSS.t160 a_280_7194.t3 a_942_7836.t1 VSS.t64 nfet_03v3 ad=0.3416p pd=2.34u as=0.1456p ps=1.08u w=0.56u l=0.28u
X168 a_n9960_n3824.t1 a_n9440_n4694.t0 VSS.t45 ppolyf_u_1k r_width=1u r_length=3.71u
X169 a_n9960_n5954.t4 a_n9960_n4694.t9 VDD.t52 VDD.t51 pfet_03v3 ad=1.2129p pd=5.185u as=1.2129p ps=5.185u w=4.665u l=0.28u
X170 VDD_VCO.t74 VSS.t175 cap_nmos_03v3 c_width=10u c_length=6u
X171 VDD_VCO.t31 a_3032_n194.t16 VDD.t107 VDD.t106 pfet_03v3 ad=1.04p pd=4.52u as=1.04p ps=4.52u w=4u l=0.28u
X172 a_3336_n12918.t2 a_4728_n12918.t1 VSS.t7 ppolyf_u_1k r_width=1u r_length=6.32u
X173 a_22272_8510.t1 a_26120_9030.t1 VSS.t2 ppolyf_u_1k r_width=1u r_length=18.6u
X174 VDD.t184 a_3032_n194.t49 VDD_VCO.t49 VDD.t183 pfet_03v3 ad=1.04p pd=4.52u as=1.04p ps=4.52u w=4u l=0.28u
X175 a_2218_7104.t1 a_n1170_5324.t7 VDD.t79 VDD.t41 pfet_03v3 ad=0.2912p pd=1.64u as=0.728p ps=3.54u w=1.12u l=0.28u
X176 VDD.t34 a_3032_n194.t13 VDD_VCO.t12 VDD.t33 pfet_03v3 ad=1.04p pd=4.52u as=1.04p ps=4.52u w=4u l=0.28u
X177 O4P.t0 O3P.t4 VSS.t155 VSS.t154 nfet_03v3 ad=0.915p pd=4.22u as=0.915p ps=4.22u w=1.5u l=0.28u
X178 VSS.t210 a_n9960_n4694.t6 a_n9960_n5954.t7 VSS.t209 nfet_03v3 ad=0.6071p pd=2.855u as=1.42435p ps=5.89u w=2.335u l=0.28u
X179 VTUNE.t5 O3P.t1 cap_nmos_03v3 c_width=1u c_length=1u
X180 D1.t9 a_n8920_n7666.t21 VSS.t151 VSS.t150 nfet_03v3 ad=0.7436p pd=3.38u as=0.7436p ps=3.38u w=2.86u l=0.28u
X181 VDD_VCO.t46 a_3032_n194.t22 VDD.t171 VDD.t170 pfet_03v3 ad=1.04p pd=4.52u as=1.04p ps=4.52u w=4u l=0.28u
X182 a_n9960_n3824.t0 a_n9960_n4694.t3 VSS.t45 ppolyf_u_1k r_width=1u r_length=3.71u
X183 a_n9960_n3176.t3 a_n9440_n4694.t1 VSS.t45 ppolyf_u_1k r_width=1u r_length=3.71u
X184 a_3032_n194.t0 a_2982_n17114.t5 VDD.t161 VDD.t160 pfet_03v3 ad=5.2p pd=17.3u as=5.2p ps=17.3u w=8u l=1u
X185 a_2672_5348.t1 a_n1170_5156.t2 VSS.t28 VSS.t27 nfet_03v3 ad=0.3416p pd=2.34u as=0.3416p ps=2.34u w=0.56u l=0.28u
X186 a_2920_n19634.t2 a_2920_n19634.t1 VSS.t203 VSS.t202 nfet_03v3 ad=2.44p pd=9.22u as=2.44p ps=9.22u w=4u l=1u
X187 VSS.t128 D1.t22 PA_DRAIN.t5 VSS.t127 nfet_03v3 ad=0.8125p pd=3.645u as=0.8125p ps=3.645u w=3.125u l=0.28u
X188 VDD.t87 a_n8920_n7666.t24 D1.t0 VDD.t86 pfet_03v3 ad=3.25p pd=11.3u as=1.3p ps=5.52u w=5u l=0.28u
X189 VSS.t23 a_26120_12150.t1 VSS.t2 ppolyf_u_1k r_width=1u r_length=18.6u
X190 a_9736_n10398.t2 a_15128_n19574.t3 VDD.t197 VDD.t196 pfet_03v3 ad=5.2p pd=17.3u as=5.2p ps=17.3u w=8u l=1u
X191 VDD_VCO.t65 VSS.t184 cap_nmos_03v3 c_width=10u c_length=6u
X192 a_n68_5252.t0 a_n278_5998.t2 VSS.t15 VSS.t14 nfet_03v3 ad=0.1456p pd=1.08u as=0.3416p ps=2.34u w=0.56u l=0.28u
X193 VDD.t182 a_3032_n194.t19 VDD_VCO.t48 VDD.t181 pfet_03v3 ad=1.04p pd=4.52u as=1.04p ps=4.52u w=4u l=0.28u
X194 O1N.t3 O3N.t5 VDD_VCO.t64 VDD_VCO.t63 pfet_03v3 ad=1.95p pd=7.3u as=1.95p ps=7.3u w=3u l=0.28u
X195 VDD.t5 a_3032_n194.t41 VDD_VCO.t1 VDD.t4 pfet_03v3 ad=1.04p pd=4.52u as=1.04p ps=4.52u w=4u l=0.28u
X196 a_n9960_n4694.t2 a_n9960_n3176.t5 VDD.t85 VDD.t84 pfet_03v3 ad=1.04p pd=4.52u as=2.6p ps=9.3u w=4u l=0.28u
X197 VSS.t120 D1.t26 PA_DRAIN.t11 VSS.t119 nfet_03v3 ad=0.8125p pd=3.645u as=0.8125p ps=3.645u w=3.125u l=0.28u
X198 a_n1158_7658.t1 a_n1820_7194.t2 VDD.t180 VDD.t96 pfet_03v3 ad=0.728p pd=3.54u as=0.728p ps=3.54u w=1.12u l=0.28u
X199 D1.t12 a_n8920_n7666.t10 VDD.t199 VDD.t198 pfet_03v3 ad=1.3p pd=5.52u as=3.25p ps=11.3u w=5u l=0.28u
X200 VSS.t165 a_n2556_7038.t4 a_n2420_7264.t1 VSS.t164 nfet_03v3 ad=0.3416p pd=2.34u as=0.3416p ps=2.34u w=0.56u l=0.28u
X201 a_2880_7844.t1 a_2218_7264.t2 a_2818_7194.t0 VSS.t17 nfet_03v3 ad=0.1456p pd=1.08u as=0.3416p ps=2.34u w=0.56u l=0.28u
X202 VSS.t85 a_n8920_n7666.t15 D1.t3 VSS.t84 nfet_03v3 ad=0.7436p pd=3.38u as=0.7436p ps=3.38u w=2.86u l=0.28u
X203 a_22272_8510.t0 a_26120_7990.t0 VSS.t2 ppolyf_u_1k r_width=1u r_length=18.6u
X204 O4P.t3 O4N.t5 VSS.t145 VSS.t144 nfet_03v3 ad=0.4697p pd=2.76u as=0.4697p ps=2.76u w=0.77u l=0.28u
X205 VDD_VCO.t52 a_3032_n194.t38 VDD.t193 VDD.t192 pfet_03v3 ad=1.04p pd=4.52u as=1.04p ps=4.52u w=4u l=0.28u
X206 a_3336_n8238.t2 a_4728_n8758.t0 VSS.t7 ppolyf_u_1k r_width=1u r_length=6.32u
X207 VDD.t146 a_9736_n10398.t3 a_3336_n12918.t1 VDD.t145 pfet_03v3 ad=3.9p pd=13.3u as=1.56p ps=6.52u w=6u l=1u
X208 PA_DRAIN.t2 D1.t19 VSS.t134 VSS.t133 nfet_03v3 ad=0.8125p pd=3.645u as=0.8125p ps=3.645u w=3.125u l=0.28u
X209 D1.t6 a_n8920_n7666.t18 VDD.t125 VDD.t124 pfet_03v3 ad=1.3p pd=5.52u as=1.3p ps=5.52u w=5u l=0.28u
X210 VSS.t60 O4P.t4 O4N.t1 VSS.t59 nfet_03v3 ad=0.4697p pd=2.76u as=0.4697p ps=2.76u w=0.77u l=0.28u
X211 VDD.t203 a_3032_n194.t25 VDD_VCO.t54 VDD.t202 pfet_03v3 ad=1.04p pd=4.52u as=1.04p ps=4.52u w=4u l=0.28u
X212 a_n8920_n7666.t6 a_n9960_n5954.t14 VDD.t144 VDD.t143 pfet_03v3 ad=1.248p pd=5.32u as=1.248p ps=5.32u w=4.8u l=0.28u
X213 VDD.t135 a_13712_n12918.t0 VSS.t3 ppolyf_u_1k r_width=1u r_length=19.24u
X214 VDD.t7 a_3032_n194.t47 VDD_VCO.t2 VDD.t6 pfet_03v3 ad=1.04p pd=4.52u as=1.04p ps=4.52u w=4u l=0.28u
X215 VSS.t62 CORE_CLK.t12 a_n1758_7844.t0 VSS.t61 nfet_03v3 ad=0.3416p pd=2.34u as=0.1456p ps=1.08u w=0.56u l=0.28u
X216 VDD.t111 a_n2418_6310.t3 a_n2358_6180.t1 VDD.t110 pfet_03v3 ad=0.728p pd=3.54u as=0.728p ps=3.54u w=1.12u l=0.28u
X217 a_n1110_5220.t0 a_n1170_5156.t4 a_n1110_5052.t0 VSS.t4 nfet_03v3 ad=93.59999f pd=0.88u as=93.59999f ps=0.88u w=0.36u l=0.32u
X218 a_n4939_60.t0 a_n3466_n200.t0 VSS.t22 ppolyf_u r_width=0.8u r_length=6.705u
X219 VDD.t50 a_n9960_n4694.t11 a_n9960_n5954.t3 VDD.t49 pfet_03v3 ad=3.03225p pd=10.63u as=1.2129p ps=5.185u w=4.665u l=0.28u
X220 VDD_VCO.t77 VSS.t172 cap_nmos_03v3 c_width=10u c_length=6u
X221 PA_DRAIN.t8 D1.t23 VSS.t126 VSS.t125 nfet_03v3 ad=0.8125p pd=3.645u as=0.8125p ps=3.645u w=3.125u l=0.28u
X222 VSS.t63 CORE_CLK.t11 a_342_7844.t1 VSS.t21 nfet_03v3 ad=0.3416p pd=2.34u as=0.1456p ps=1.08u w=0.56u l=0.28u
X223 a_n2418_6310.t0 a_n1690_5488.t2 a_n1630_5384.t1 VSS.t65 nfet_03v3 ad=0.228p pd=1.98u as=93.59999f ps=0.88u w=0.36u l=0.36u
X224 VDD_VCO.t79 VSS.t170 cap_nmos_03v3 c_width=10u c_length=6u
X225 VDD_VCO.t27 a_3032_n194.t44 VDD.t89 VDD.t88 pfet_03v3 ad=1.04p pd=4.52u as=1.04p ps=4.52u w=4u l=0.28u
X226 a_2982_n17114.t2 a_2920_n19634.t5 VSS.t54 VSS.t53 nfet_03v3 ad=1.83p pd=7.22u as=1.83p ps=7.22u w=3u l=1u
X227 VDD.t30 a_n1170_5156.t7 a_3282_5984.t0 VDD.t29 pfet_03v3 ad=0.728p pd=3.54u as=0.2912p ps=1.64u w=1.12u l=0.28u
X228 VDD_VCO.t76 VSS.t173 cap_nmos_03v3 c_width=10u c_length=6u
X229 VSS.t153 a_n8920_n7666.t23 D1.t11 VSS.t152 nfet_03v3 ad=1.7446p pd=6.94u as=0.7436p ps=3.38u w=2.86u l=0.28u
D1 O1N.t7 DOUBLER_K sc_diode pj=3.24u area=0.62p
X230 a_n1170_5324.t1 a_2818_7194.t2 VDD.t152 VDD.t151 pfet_03v3 ad=0.728p pd=3.54u as=0.728p ps=3.54u w=1.12u l=0.28u
X231 VDD.t138 a_19812_n12918.t0 VSS.t13 ppolyf_u_1k r_width=1u r_length=19.74u
X232 a_22272_11630.t0 a_26120_12150.t0 VSS.t2 ppolyf_u_1k r_width=1u r_length=18.6u
X233 VDD_VCO.t59 a_3032_n194.t50 VDD.t212 VDD.t211 pfet_03v3 ad=1.04p pd=4.52u as=1.04p ps=4.52u w=4u l=0.28u
X234 a_22018_6314.t2 a_22018_6314.t1 VDD.t142 VDD.t141 pfet_03v3 ad=2.6p pd=9.3u as=2.6p ps=9.3u w=4u l=2u
X235 VDD_VCO.t68 VSS.t181 cap_nmos_03v3 c_width=10u c_length=6u
X236 RF_DRV1.t0 a_n9440_766.t1 VSS.t8 ppolyf_u_1k r_width=1u r_length=5.37u
X237 a_n11000_118.t1 a_n10480_n1140.t1 VSS.t6 ppolyf_u_1k r_width=1u r_length=5.65u
X238 VSS.t220 O3N.t4 O4N.t3 VSS.t219 nfet_03v3 ad=0.915p pd=4.22u as=0.915p ps=4.22u w=1.5u l=0.28u
X239 VSS.t89 O2N.t5 O2P.t3 VSS.t88 nfet_03v3 ad=0.4697p pd=2.76u as=0.4697p ps=2.76u w=0.77u l=0.28u
X240 VDD.t56 a_n9960_n3176.t7 a_n9960_n4694.t0 VDD.t55 pfet_03v3 ad=2.6p pd=9.3u as=1.04p ps=4.52u w=4u l=0.28u
X241 a_3336_n12918.t4 a_10742_n10398.t0 cap_mim_2f0_m5m6_noshield c_width=28.7u c_length=38.5u
X242 VDD_VCO.t8 a_3032_n194.t14 VDD.t19 VDD.t18 pfet_03v3 ad=1.04p pd=4.52u as=1.04p ps=4.52u w=4u l=0.28u
X243 VDD.t177 a_n9960_n5954.t8 a_n8920_n7666.t8 VDD.t176 pfet_03v3 ad=1.248p pd=5.32u as=3.12p ps=10.9u w=4.8u l=0.28u
X244 VSS.t140 D1.t16 PA_DRAIN.t7 VSS.t139 nfet_03v3 ad=0.8125p pd=3.645u as=0.8125p ps=3.645u w=3.125u l=0.28u
X245 VSS.t69 a_n1170_5324.t8 a_2218_7264.t1 VSS.t68 nfet_03v3 ad=0.3416p pd=2.34u as=0.3416p ps=2.34u w=0.56u l=0.28u
X246 VDD.t155 a_n1170_5324.t6 a_1922_5998.t1 VDD.t154 pfet_03v3 ad=0.728p pd=3.54u as=0.728p ps=3.54u w=1.12u l=0.28u
X247 a_n1690_5488.t1 a_n2588_5202.t3 a_n1110_5556.t1 VSS.t4 nfet_03v3 ad=0.228p pd=1.98u as=93.59999f ps=0.88u w=0.36u l=0.32u
X248 a_2732_5244.t0 a_n1170_5324.t2 VSS.t72 VSS.t71 nfet_03v3 ad=0.1456p pd=1.08u as=0.3416p ps=2.34u w=0.56u l=0.28u
X249 a_n9960_n5342.t1 a_n9440_n5954.t0 VSS.t24 ppolyf_u_1k r_width=1u r_length=2.42u
X250 a_n8920_n7666.t9 a_n9960_n5954.t9 VSS.t163 VSS.t162 nfet_03v3 ad=0.78p pd=3.52u as=1.83p ps=7.22u w=3u l=0.28u
X251 D1.t5 a_n8920_n7666.t17 VSS.t87 VSS.t86 nfet_03v3 ad=0.7436p pd=3.38u as=0.7436p ps=3.38u w=2.86u l=0.28u
X252 a_3480_7836.t0 a_1550_7204.t4 a_n1170_5324.t0 VSS.t44 nfet_03v3 ad=0.1456p pd=1.08u as=0.3416p ps=2.34u w=0.56u l=0.28u
X253 VSS.t216 a_n12040_766.t4 a_n11000_n1140.t3 VSS.t215 nfet_03v3 ad=0.976p pd=4.42u as=0.976p ps=4.42u w=1.6u l=0.28u
X254 VDD.t188 a_3032_n194.t11 VDD_VCO.t51 VDD.t187 pfet_03v3 ad=1.04p pd=4.52u as=1.04p ps=4.52u w=4u l=0.28u
X255 VDD_VCO.t73 VSS.t176 cap_nmos_03v3 c_width=10u c_length=6u
X256 a_n1158_7836.t1 CORE_CLK.t10 a_n1158_7658.t0 VSS.t29 nfet_03v3 ad=0.1456p pd=1.08u as=0.3416p ps=2.34u w=0.56u l=0.28u
X257 a_n2420_7104.t0 a_n2556_7038.t3 VDD.t63 VDD.t62 pfet_03v3 ad=0.2912p pd=1.64u as=0.728p ps=3.54u w=1.12u l=0.28u
X258 VDD.t99 CORE_CLK.t4 a_n1145_6254.t0 VDD.t98 pfet_03v3 ad=0.468p pd=2.74u as=0.1872p ps=1.24u w=0.72u l=0.32u
X259 VDD.t77 a_3032_n194.t33 VDD_VCO.t22 VDD.t76 pfet_03v3 ad=1.04p pd=4.52u as=1.04p ps=4.52u w=4u l=0.28u
X260 VDD.t58 a_n9960_n5954.t16 a_n8920_n7666.t4 VDD.t57 pfet_03v3 ad=3.12p pd=10.9u as=1.248p ps=5.32u w=4.8u l=0.28u
X261 a_2982_n17114.t1 a_2982_n17114.t0 VDD.t117 VDD.t116 pfet_03v3 ad=5.2p pd=17.3u as=5.2p ps=17.3u w=8u l=1u
X262 VSS.t132 D1.t20 PA_DRAIN.t3 VSS.t131 nfet_03v3 ad=0.8125p pd=3.645u as=0.8125p ps=3.645u w=3.125u l=0.28u
X263 VDD.t148 a_n1690_5488.t3 a_n2418_6310.t1 VDD.t147 pfet_03v3 ad=0.2432p pd=2.06u as=0.2432p ps=2.06u w=0.36u l=0.36u
X264 VDD.t32 a_n1170_5156.t8 a_n278_5998.t0 VDD.t31 pfet_03v3 ad=0.728p pd=3.54u as=0.728p ps=3.54u w=1.12u l=0.28u
X265 a_3282_5984.t1 a_n1170_5324.t5 a_2672_5348.t0 VDD.t61 pfet_03v3 ad=0.2912p pd=1.64u as=0.728p ps=3.54u w=1.12u l=0.28u
X266 a_532_5244.t1 a_n1170_5156.t3 VSS.t196 VSS.t195 nfet_03v3 ad=0.1456p pd=1.08u as=0.3416p ps=2.34u w=0.56u l=0.28u
X267 a_n11000_118.t0 a_n11000_n1140.t0 VSS.t6 ppolyf_u_1k r_width=1u r_length=5.65u
X268 VDD_VCO.t15 a_3032_n194.t20 VDD.t46 VDD.t45 pfet_03v3 ad=1.04p pd=4.52u as=1.04p ps=4.52u w=4u l=0.28u
X269 a_3336_n12918.t0 a_2920_n19634.t3 VSS.t52 VSS.t51 nfet_03v3 ad=4.27p pd=15.22u as=4.27p ps=15.22u w=7u l=1u
X270 VSS.t94 a_n11000_n1140.t4 a_n9960_n3176.t1 VSS.t93 nfet_03v3 ad=1.525p pd=6.22u as=1.525p ps=6.22u w=2.5u l=0.28u
X271 a_9124_n19574.t1 a_2920_n19634.t4 VSS.t75 VSS.t74 nfet_03v3 ad=1.83p pd=7.22u as=1.83p ps=7.22u w=3u l=1u
X272 VTUNE.t6 O1N.t1 cap_nmos_03v3 c_width=1u c_length=1u
X273 VDD.t157 MIM_TOP.t3 RF_DRV1.t3 VDD.t156 pfet_03v3 ad=1.3p pd=5.3u as=1.3p ps=5.3u w=2u l=0.28u
X274 a_n9960_n5342.t0 a_n9960_n5954.t6 VSS.t24 ppolyf_u_1k r_width=1u r_length=2.42u
X275 a_n9960_n4694.t5 a_n9440_n5954.t1 VSS.t24 ppolyf_u_1k r_width=1u r_length=2.42u
X276 a_22272_11630.t1 a_26120_11110.t0 VSS.t2 ppolyf_u_1k r_width=1u r_length=18.6u
X277 VDD.t150 a_3032_n194.t17 VDD_VCO.t40 VDD.t149 pfet_03v3 ad=1.04p pd=4.52u as=1.04p ps=4.52u w=4u l=0.28u
X278 a_n2218_3378.t1 O1P.t8 a_n866_2740.t2 VSS.t39 nfet_03v3 ad=0.61p pd=3.22u as=0.61p ps=3.22u w=1u l=0.28u
X279 O1N.t0 O1P.t6 VSS.t212 VSS.t211 nfet_03v3 ad=0.4697p pd=2.76u as=0.4697p ps=2.76u w=0.77u l=0.28u
X280 VDD.t113 a_3032_n194.t39 VDD_VCO.t33 VDD.t112 pfet_03v3 ad=1.04p pd=4.52u as=1.04p ps=4.52u w=4u l=0.28u
X281 a_n1170_5156.t0 a_n1170_5324.t3 a_2132_5252.t0 VSS.t31 nfet_03v3 ad=0.3416p pd=2.34u as=0.1456p ps=1.08u w=0.56u l=0.28u
X282 a_n1134_3368.t0 O1N.t8 a_n866_2740.t0 VSS.t39 nfet_03v3 ad=0.61p pd=3.22u as=0.61p ps=3.22u w=1u l=0.28u
X283 VSS.t208 O2P.t6 O3P.t2 VSS.t207 nfet_03v3 ad=0.915p pd=4.22u as=0.915p ps=4.22u w=1.5u l=0.28u
X284 VDD_VCO.t14 a_3032_n194.t36 VDD.t44 VDD.t43 pfet_03v3 ad=1.04p pd=4.52u as=1.04p ps=4.52u w=4u l=0.28u
X285 VSS.t43 O1N.t5 O1P.t0 VSS.t42 nfet_03v3 ad=0.4697p pd=2.76u as=0.4697p ps=2.76u w=0.77u l=0.28u
X286 VDD_VCO.t24 O1N.t6 O3P.t0 VDD_VCO.t23 pfet_03v3 ad=1.95p pd=7.3u as=1.95p ps=7.3u w=3u l=0.28u
X287 a_17294_n17114.t1 a_25264_n11438.t0 VSS.t32 ppolyf_u_1k r_width=1u r_length=16u
X288 a_942_7836.t0 CORE_CLK.t9 a_n2588_5202.t0 VSS.t64 nfet_03v3 ad=0.1456p pd=1.08u as=0.3416p ps=2.34u w=0.56u l=0.28u
X289 VDD.t13 a_3032_n194.t45 VDD_VCO.t5 VDD.t12 pfet_03v3 ad=1.04p pd=4.52u as=1.04p ps=4.52u w=4u l=0.28u
X290 VDD_VCO.t50 a_3032_n194.t8 VDD.t186 VDD.t185 pfet_03v3 ad=1.04p pd=4.52u as=1.04p ps=4.52u w=4u l=0.28u
X291 a_15128_n19574.t2 a_15128_n19574.t1 VDD.t81 VDD.t80 pfet_03v3 ad=5.2p pd=17.3u as=5.2p ps=17.3u w=8u l=1u
X292 TAIL_BIAS.t4 VSS.t186 cap_nmos_03v3 c_width=20u c_length=6u
X293 a_n1820_7194.t0 CORE_CLK.t6 VDD.t97 VDD.t96 pfet_03v3 ad=0.728p pd=3.54u as=0.728p ps=3.54u w=1.12u l=0.28u
X294 TAIL_BIAS.t0 a_22018_6314.t3 VDD.t103 VDD.t102 pfet_03v3 ad=2.6p pd=9.3u as=2.6p ps=9.3u w=4u l=2u
X295 O4P.t2 O2N.t4 VDD_VCO.t36 VDD_VCO.t35 pfet_03v3 ad=1.95p pd=7.3u as=1.95p ps=7.3u w=3u l=0.28u
X296 a_3336_n12918.t3 a_9736_n10398.t4 VDD.t208 VDD.t207 pfet_03v3 ad=1.56p pd=6.52u as=3.9p ps=13.3u w=6u l=1u
X297 a_3336_n12398.t1 a_4728_n12918.t0 VSS.t7 ppolyf_u_1k r_width=1u r_length=6.32u
X298 VTUNE.t3 O2P.t0 cap_nmos_03v3 c_width=1u c_length=1u
X299 VDD_VCO.t0 a_3032_n194.t42 VDD.t1 VDD.t0 pfet_03v3 ad=1.04p pd=4.52u as=1.04p ps=4.52u w=4u l=0.28u
X300 VSS.t12 a_n9960_n5954.t11 a_n8920_n7666.t2 VSS.t11 nfet_03v3 ad=0.78p pd=3.52u as=0.78p ps=3.52u w=3u l=0.28u
X301 a_15128_n19574.t0 a_3336_n12918.t5 a_9124_n19574.t2 VSS.t105 nfet_03v3 ad=4.88p pd=17.22u as=4.88p ps=17.22u w=8u l=1u
X302 VDD_VCO.t25 a_25264_n12918.t0 VSS.t32 ppolyf_u_1k r_width=1u r_length=16u
X303 a_24874_6374.t1 a_22018_6314.t5 VDD.t216 VDD.t215 pfet_03v3 ad=0.676p pd=3.38u as=0.676p ps=3.38u w=1.04u l=5u
X304 a_n4939_2280.t1 a_n3466_2020.t1 VSS.t16 ppolyf_u r_width=0.8u r_length=6.705u
X305 a_n9960_n5954.t1 a_n9960_n4694.t8 VSS.t1 VSS.t0 nfet_03v3 ad=0.6071p pd=2.855u as=0.6071p ps=2.855u w=2.335u l=0.28u
X306 VDD_VCO.t70 VSS.t179 cap_nmos_03v3 c_width=10u c_length=6u
X307 VTUNE.t4 O3N.t0 cap_nmos_03v3 c_width=1u c_length=1u
X308 VDD_VCO.t9 a_3032_n194.t28 VDD.t21 VDD.t20 pfet_03v3 ad=1.04p pd=4.52u as=1.04p ps=4.52u w=4u l=0.28u
X309 VDD_VCO.t82 VSS.t167 cap_nmos_03v3 c_width=10u c_length=6u
X310 VDD.t201 a_n8920_n7666.t12 D1.t14 VDD.t200 pfet_03v3 ad=1.3p pd=5.52u as=1.3p ps=5.52u w=5u l=0.28u
X311 VDD.t115 RF_DRV1.t5 a_n12040_766.t2 VDD.t114 pfet_03v3 ad=1.3p pd=5.3u as=1.3p ps=5.3u w=2u l=0.28u
X312 a_n4939_60.t1 DOUBLER_K.t2 VSS.t92 ppolyf_u r_width=0.8u r_length=6.705u
X313 VDD_VCO.t45 O3P.t6 O1P.t2 VDD_VCO.t44 pfet_03v3 ad=1.95p pd=7.3u as=1.95p ps=7.3u w=3u l=0.28u
X314 VDD.t15 a_3032_n194.t15 VDD_VCO.t6 VDD.t14 pfet_03v3 ad=1.04p pd=4.52u as=1.04p ps=4.52u w=4u l=0.28u
X315 VTUNE.t1 O4P.t1 cap_nmos_03v3 c_width=1u c_length=1u
X316 O2N.t3 O4N.t4 VDD_VCO.t42 VDD_VCO.t41 pfet_03v3 ad=1.95p pd=7.3u as=1.95p ps=7.3u w=3u l=0.28u
X317 VDD_VCO.t72 VSS.t177 cap_nmos_03v3 c_width=10u c_length=6u
X318 VSS.t10 a_n2588_5202.t7 a_1550_7204.t1 VSS.t9 nfet_03v3 ad=0.3416p pd=2.34u as=0.3416p ps=2.34u w=0.56u l=0.28u
X319 a_22018_6314.t0 a_26120_7990.t1 VSS.t2 ppolyf_u_1k r_width=1u r_length=18.6u
X320 a_n1110_5052.t1 PRESCALED.t2 a_n1110_4884.t0 VSS.t4 nfet_03v3 ad=93.59999f pd=0.88u as=93.59999f ps=0.88u w=0.36u l=0.32u
X321 VSS.t218 O3N.t6 O3P.t3 VSS.t217 nfet_03v3 ad=0.4697p pd=2.76u as=0.4697p ps=2.76u w=0.77u l=0.28u
X322 a_22272_10590.t0 a_26120_11110.t1 VSS.t2 ppolyf_u_1k r_width=1u r_length=18.6u
X323 VDD_VCO.t13 a_3032_n194.t12 VDD.t36 VDD.t35 pfet_03v3 ad=1.04p pd=4.52u as=1.04p ps=4.52u w=4u l=0.28u
X324 PA_DRAIN.t12 D1.t27 VSS.t118 VSS.t117 nfet_03v3 ad=0.8125p pd=3.645u as=0.8125p ps=3.645u w=3.125u l=0.28u
X325 VDD_VCO.t21 a_3032_n194.t34 VDD.t75 VDD.t74 pfet_03v3 ad=1.04p pd=4.52u as=1.04p ps=4.52u w=4u l=0.28u
X326 a_21936_n10918.t1 a_25264_n11438.t1 VSS.t32 ppolyf_u_1k r_width=1u r_length=16u
X327 VDD.t163 a_n278_5998.t3 PRESCALED.t0 VDD.t162 pfet_03v3 ad=0.728p pd=3.54u as=0.728p ps=3.54u w=1.12u l=0.28u
X328 a_n12040_1968.t1 a_n12040_766.t3 VSS.t8 ppolyf_u_1k r_width=1u r_length=5.37u
X329 O2N.t1 O2P.t4 VSS.t206 VSS.t205 nfet_03v3 ad=0.4697p pd=2.76u as=0.4697p ps=2.76u w=0.77u l=0.28u
X330 a_3336_n12398.t0 a_4728_n11878.t0 VSS.t7 ppolyf_u_1k r_width=1u r_length=6.32u
X331 VDD_VCO.t67 VSS.t182 cap_nmos_03v3 c_width=10u c_length=6u
X332 VDD.t93 a_3032_n194.t31 VDD_VCO.t28 VDD.t92 pfet_03v3 ad=1.04p pd=4.52u as=1.04p ps=4.52u w=4u l=0.28u
X333 VDD.t165 a_n8920_n7666.t20 D1.t8 VDD.t164 pfet_03v3 ad=1.3p pd=5.52u as=1.3p ps=5.52u w=5u l=0.28u
R0 VCTRL VCTRL.t0 67.907
R1 PA_DRAIN.n2 PA_DRAIN.n0 14.6339
R2 PA_DRAIN.n2 PA_DRAIN.n1 14.5539
R3 PA_DRAIN.n4 PA_DRAIN.n3 14.5539
R4 PA_DRAIN.n6 PA_DRAIN.n5 14.5539
R5 PA_DRAIN.n8 PA_DRAIN.n7 14.5539
R6 PA_DRAIN.n10 PA_DRAIN.n9 14.5539
R7 PA_DRAIN.n12 PA_DRAIN.n11 14.5539
R8 PA_DRAIN.n14 PA_DRAIN.n13 14.5539
R9 PA_DRAIN.n0 PA_DRAIN.t15 0.52466
R10 PA_DRAIN.n0 PA_DRAIN.t14 0.52466
R11 PA_DRAIN.n1 PA_DRAIN.t13 0.52466
R12 PA_DRAIN.n1 PA_DRAIN.t12 0.52466
R13 PA_DRAIN.n3 PA_DRAIN.t11 0.52466
R14 PA_DRAIN.n3 PA_DRAIN.t10 0.52466
R15 PA_DRAIN.n5 PA_DRAIN.t9 0.52466
R16 PA_DRAIN.n5 PA_DRAIN.t8 0.52466
R17 PA_DRAIN.n7 PA_DRAIN.t5 0.52466
R18 PA_DRAIN.n7 PA_DRAIN.t4 0.52466
R19 PA_DRAIN.n9 PA_DRAIN.t3 0.52466
R20 PA_DRAIN.n9 PA_DRAIN.t2 0.52466
R21 PA_DRAIN.n11 PA_DRAIN.t1 0.52466
R22 PA_DRAIN.n11 PA_DRAIN.t0 0.52466
R23 PA_DRAIN.n13 PA_DRAIN.t7 0.52466
R24 PA_DRAIN.n13 PA_DRAIN.t6 0.52466
R25 PA_DRAIN PA_DRAIN.n14 0.118
R26 PA_DRAIN.n4 PA_DRAIN.n2 0.0805
R27 PA_DRAIN.n6 PA_DRAIN.n4 0.0805
R28 PA_DRAIN.n8 PA_DRAIN.n6 0.0805
R29 PA_DRAIN.n10 PA_DRAIN.n8 0.0805
R30 PA_DRAIN.n12 PA_DRAIN.n10 0.0805
R31 PA_DRAIN.n14 PA_DRAIN.n12 0.0805
R32 D1.n0 D1.t15 60.3328
R33 D1.n13 D1.t29 60.1434
R34 D1.n12 D1.t28 60.1434
R35 D1.n11 D1.t27 60.1434
R36 D1.n10 D1.t26 60.1434
R37 D1.n9 D1.t25 60.1434
R38 D1.n8 D1.t24 60.1434
R39 D1.n7 D1.t23 60.1434
R40 D1.n6 D1.t22 60.1434
R41 D1.n5 D1.t21 60.1434
R42 D1.n4 D1.t20 60.1434
R43 D1.n3 D1.t19 60.1434
R44 D1.n2 D1.t18 60.1434
R45 D1.n1 D1.t17 60.1434
R46 D1.n0 D1.t16 60.1434
R47 D1 D1.t30 60.1434
R48 D1.n19 D1.t13 6.84767
R49 D1.n16 D1.n14 6.44227
R50 D1.n22 D1.n20 6.01347
R51 D1.n18 D1.n17 5.96655
R52 D1.n16 D1.n15 5.96655
R53 D1.n26 D1.n25 5.53775
R54 D1.n24 D1.n23 5.53775
R55 D1.n22 D1.n21 5.53775
R56 D1 D1.n27 5.16738
R57 D1.n27 D1.n19 1.68479
R58 D1.n27 D1.n26 1.37621
R59 D1.n17 D1.t3 0.573227
R60 D1.n17 D1.t1 0.573227
R61 D1.n15 D1.t7 0.573227
R62 D1.n15 D1.t5 0.573227
R63 D1.n14 D1.t11 0.573227
R64 D1.n14 D1.t9 0.573227
R65 D1.n19 D1.n18 0.521214
R66 D1.n24 D1.n22 0.476214
R67 D1.n26 D1.n24 0.476214
R68 D1.n18 D1.n16 0.476214
R69 D1.n25 D1.t14 0.3645
R70 D1.n25 D1.t12 0.3645
R71 D1.n23 D1.t4 0.3645
R72 D1.n23 D1.t2 0.3645
R73 D1.n21 D1.t8 0.3645
R74 D1.n21 D1.t6 0.3645
R75 D1.n20 D1.t0 0.3645
R76 D1.n20 D1.t10 0.3645
R77 D1.n13 D1.n12 0.189974
R78 D1.n12 D1.n11 0.189974
R79 D1.n11 D1.n10 0.189974
R80 D1.n10 D1.n9 0.189974
R81 D1.n9 D1.n8 0.189974
R82 D1.n8 D1.n7 0.189974
R83 D1.n7 D1.n6 0.189974
R84 D1.n6 D1.n5 0.189974
R85 D1.n5 D1.n4 0.189974
R86 D1.n4 D1.n3 0.189974
R87 D1.n3 D1.n2 0.189974
R88 D1.n2 D1.n1 0.189974
R89 D1.n1 D1.n0 0.189974
R90 D1 D1.n13 0.144974
R91 O2N.n0 O2N.t4 75.1037
R92 O2N.n0 O2N.t6 45.8816
R93 O2N.n1 O2N.t5 29.5094
R94 O2N.n2 O2N.t1 9.89919
R95 O2N.n3 O2N.t0 5.83651
R96 O2N O2N.t2 4.8305
R97 O2N.n1 O2N.n0 4.5005
R98 O2N.n3 O2N.t3 2.34277
R99 O2N.n2 O2N.n1 1.59898
R100 O2N.n4 O2N.n3 0.68137
R101 O2N O2N.n4 0.360243
R102 O2N.n4 O2N.n2 0.0591957
R103 O4P.n0 O4P.t5 63.0791
R104 O4P.n0 O4P.t6 45.3692
R105 O4P.n1 O4P.t4 29.5094
R106 O4P O4P.t3 9.60046
R107 O4P.n2 O4P.t1 5.85967
R108 O4P.n1 O4P.n0 5.40565
R109 O4P.n3 O4P.t0 5.20589
R110 O4P.n2 O4P.t2 2.37525
R111 O4P.n4 O4P.n1 1.60289
R112 O4P.n3 O4P.n2 0.554196
R113 O4P O4P.n4 0.283578
R114 O4P.n4 O4P.n3 0.0591957
R115 O3N.n2 O3N.t5 63.0791
R116 O3N.n2 O3N.t4 56.1802
R117 O3N.n0 O3N.t6 31.1079
R118 O3N.n3 O3N.n2 14.2002
R119 O3N.n0 O3N.t2 9.89919
R120 O3N.n1 O3N.t0 5.51194
R121 O3N O3N.t1 4.8305
R122 O3N.n1 O3N.t3 2.0205
R123 O3N.n4 O3N.n3 0.923978
R124 O3N O3N.n4 0.360243
R125 O3N.n3 O3N.n1 0.0838684
R126 O3N.n4 O3N.n0 0.0591957
R127 O2P.n4 O2P.t5 67.5834
R128 O2P O2P.t6 43.5255
R129 O2P.n0 O2P.t4 31.1146
R130 O2P.n4 O2P.n3 10.1243
R131 O2P.n0 O2P.t3 9.88354
R132 O2P.n2 O2P.t0 5.60495
R133 O2P O2P.n4 7.0947
R134 O2P.n1 O2P.t1 5.20589
R135 O2P.n3 O2P.t2 2.07971
R136 O2P.n2 O2P.n1 0.612891
R137 O2P.n3 O2P.n2 0.230587
R138 O2P.n1 O2P.n0 0.0591957
R139 O4N.n0 O4N.t4 66.559
R140 O4N.n0 O4N.t6 46.765
R141 O4N.n2 O4N.t5 29.5705
R142 O4N.n3 O4N.t1 9.89919
R143 O4N.n2 O4N.t0 5.31523
R144 O4N O4N.t3 4.8305
R145 O4N.n1 O4N.n0 4.73971
R146 O4N.n1 O4N.t2 2.0205
R147 O4N.n3 O4N.n2 1.54986
R148 O4N.n4 O4N.n1 1.01315
R149 O4N O4N.n4 0.360243
R150 O4N.n4 O4N.n3 0.0591957
R151 O3P.n4 O3P.t6 68.7094
R152 O3P O3P.t4 43.5255
R153 O3P.n0 O3P.t5 31.1146
R154 O3P O3P.n4 20.6216
R155 O3P.n0 O3P.t3 9.88354
R156 O3P.n4 O3P.n3 9.0005
R157 O3P.n2 O3P.t1 6.21719
R158 O3P.n1 O3P.t2 5.20589
R159 O3P.n3 O3P.t0 2.08208
R160 O3P.n2 O3P.n1 0.616804
R161 O3P.n3 O3P.n2 0.224424
R162 O3P.n1 O3P.n0 0.0591957
R163 MIM_TOP.n0 MIM_TOP.t3 45.5434
R164 MIM_TOP MIM_TOP.t2 32.5076
R165 MIM_TOP.n1 MIM_TOP.t1 23.055
R166 MIM_TOP.n0 MIM_TOP.t0 12.2404
R167 MIM_TOP.n1 MIM_TOP.n0 0.497457
R168 MIM_TOP MIM_TOP.n1 0.250935
R169 RF_DRV1.n2 RF_DRV1.t5 45.5434
R170 RF_DRV1.n2 RF_DRV1.t0 33.5789
R171 RF_DRV1.n3 RF_DRV1.t4 33.1732
R172 RF_DRV1.n1 RF_DRV1.t1 22.8339
R173 RF_DRV1 RF_DRV1.n3 11.8419
R174 RF_DRV1 RF_DRV1.n1 11.1082
R175 RF_DRV1.n0 RF_DRV1.t2 9.0318
R176 RF_DRV1.n0 RF_DRV1.t3 3.49875
R177 RF_DRV1.n1 RF_DRV1.n0 0.593326
R178 RF_DRV1.n3 RF_DRV1.n2 0.377079
R179 O1N.n0 O1N.t6 66.2998
R180 O1N.n0 O1N.t4 57.5208
R181 O1N.n5 O1N.t8 50.5431
R182 O1N.n3 O1N.t5 31.1146
R183 O1N.n4 O1N.t7 14.3684
R184 O1N.n6 O1N.n5 14.0546
R185 O1N.n6 O1N.t0 9.57323
R186 O1N.n4 O1N.t1 20.352
R187 O1N.n2 O1N.t2 5.20589
R188 O1N.n1 O1N.n0 4.5005
R189 O1N.n1 O1N.t3 2.08918
R190 O1N.n2 O1N.n1 0.923978
R191 O1N.n5 O1N.n4 0.550143
R192 O1N O1N.n3 0.281799
R193 O1N.n3 O1N.n2 0.0591957
R194 O1N O1N.n6 0.026375
R195 VTUNE.n0 VTUNE.t5 32.6395
R196 VTUNE.n3 VTUNE.t2 32.212
R197 VTUNE.n4 VTUNE.t6 31.7395
R198 VTUNE.n3 VTUNE.t1 31.7395
R199 VTUNE.n0 VTUNE.t4 31.7395
R200 VTUNE.n1 VTUNE.t3 31.7395
R201 VTUNE.n2 VTUNE.t0 31.7395
R202 VTUNE VTUNE.n4 18.518
R203 VTUNE VTUNE.t7 13.7395
R204 VTUNE.n4 VTUNE.n3 7.55825
R205 VTUNE.n3 VTUNE.n2 4.23725
R206 VTUNE.n1 VTUNE.n0 0.9005
R207 VTUNE.n2 VTUNE.n1 0.9005
R208 O1P.n1 O1P.t5 77.3804
R209 O1P.n1 O1P.t4 48.5871
R210 O1P.n2 O1P.t8 45.2041
R211 O1P.n4 O1P.t6 29.5094
R212 O1P.n2 O1P.t7 10.5643
R213 O1P.n5 O1P.t0 9.89919
R214 O1P.n0 O1P.t3 16.9132
R215 O1P.n3 O1P.n1 7.74927
R216 O1P.n3 O1P.n2 4.93121
R217 O1P O1P.t1 4.8305
R218 O1P.n4 O1P.n3 4.5894
R219 O1P.n0 O1P.t2 2.0205
R220 O1P.n5 O1P.n4 1.59898
R221 O1P.n6 O1P.n0 1.01315
R222 O1P O1P.n6 0.360243
R223 O1P.n6 O1P.n5 0.0591957
R224 MC MC.t0 39.4103
R225 PRESCALED.n0 PRESCALED.t4 38.5719
R226 PRESCALED.n0 PRESCALED.t3 32.593
R227 PRESCALED.n1 PRESCALED.t2 25.1851
R228 PRESCALED PRESCALED.n2 13.5005
R229 PRESCALED.n1 PRESCALED.t1 10.8005
R230 PRESCALED.n2 PRESCALED.n1 10.5924
R231 PRESCALED.n1 PRESCALED.t0 6.00776
R232 PRESCALED.n2 PRESCALED.n0 5.09787
R233 TAIL_BIAS TAIL_BIAS.t6 60.7951
R234 TAIL_BIAS.n3 TAIL_BIAS.t2 25.457
R235 TAIL_BIAS.n2 TAIL_BIAS.t0 22.9713
R236 TAIL_BIAS.n4 TAIL_BIAS.t1 18.3972
R237 TAIL_BIAS.n0 TAIL_BIAS.t3 12.858
R238 TAIL_BIAS.n1 TAIL_BIAS.t5 12.8512
R239 TAIL_BIAS.n0 TAIL_BIAS.t4 11.247
R240 TAIL_BIAS.n2 TAIL_BIAS.n1 10.985
R241 TAIL_BIAS TAIL_BIAS.n4 10.0299
R242 TAIL_BIAS.n3 TAIL_BIAS.n2 2.9255
R243 TAIL_BIAS.n4 TAIL_BIAS.n3 0.7655
R244 TAIL_BIAS.n1 TAIL_BIAS.n0 0.00725
R245 CP_IBIAS CP_IBIAS.t0 34.8765
R246 CORE_CLK.n1 CORE_CLK.t5 34.9895
R247 CORE_CLK.n3 CORE_CLK.t6 34.9895
R248 CORE_CLK.n0 CORE_CLK.t7 34.3028
R249 CORE_CLK.n2 CORE_CLK.t8 34.3028
R250 CORE_CLK.n0 CORE_CLK.t11 30.5324
R251 CORE_CLK.n2 CORE_CLK.t12 30.5324
R252 CORE_CLK.n1 CORE_CLK.t9 30.1998
R253 CORE_CLK.n4 CORE_CLK.t10 29.3232
R254 CORE_CLK.n6 CORE_CLK.t4 27.3622
R255 CORE_CLK.n8 CORE_CLK.t2 25.9659
R256 CORE_CLK CORE_CLK.n9 22.8244
R257 CORE_CLK.n7 CORE_CLK.t3 22.6005
R258 CORE_CLK CORE_CLK.n8 18.381
R259 CORE_CLK.n8 CORE_CLK.n7 5.3988
R260 CORE_CLK.n9 CORE_CLK.t1 3.3605
R261 CORE_CLK.n3 CORE_CLK.n2 2.47746
R262 CORE_CLK.n9 CORE_CLK.t0 2.373
R263 CORE_CLK.n7 CORE_CLK.n6 2.33267
R264 CORE_CLK.n5 CORE_CLK.n4 1.79659
R265 CORE_CLK.n5 CORE_CLK.n1 1.43659
R266 CORE_CLK.n5 CORE_CLK.n0 1.04137
R267 CORE_CLK.n4 CORE_CLK.n3 0.877022
R268 CORE_CLK.n6 CORE_CLK.n5 0.434848
R269 VDD_VCO.n89 VDD_VCO.t23 1036.59
R270 VDD_VCO.n89 VDD_VCO.t44 1036.59
R271 VDD_VCO.n100 VDD_VCO.t41 1036.59
R272 VDD_VCO.n100 VDD_VCO.t35 1036.59
R273 VDD_VCO.n95 VDD_VCO.t63 275.774
R274 VDD_VCO.n95 VDD_VCO.t56 275.774
R275 VDD_VCO.n94 VDD_VCO.t60 275.774
R276 VDD_VCO.n94 VDD_VCO.t29 275.774
R277 VDD_VCO.n96 VDD_VCO.n94 272.728
R278 VDD_VCO.n96 VDD_VCO.n95 231.405
R279 VDD_VCO.n83 VDD_VCO.t25 39.2495
R280 VDD_VCO.n97 VDD_VCO.n96 26.1095
R281 VDD_VCO.n84 VDD_VCO.n83 24.9282
R282 VDD_VCO.n90 VDD_VCO.n89 17.1005
R283 VDD_VCO.n101 VDD_VCO.n100 17.1005
R284 VDD_VCO.n26 VDD_VCO.n20 13.5005
R285 VDD_VCO.n29 VDD_VCO.n28 13.5005
R286 VDD_VCO.n30 VDD_VCO.n18 13.5005
R287 VDD_VCO.n32 VDD_VCO.n31 13.5005
R288 VDD_VCO.n34 VDD_VCO.n16 13.5005
R289 VDD_VCO.n37 VDD_VCO.n36 13.5005
R290 VDD_VCO.n38 VDD_VCO.n14 13.5005
R291 VDD_VCO.n40 VDD_VCO.n39 13.5005
R292 VDD_VCO.n42 VDD_VCO.n12 13.5005
R293 VDD_VCO.n45 VDD_VCO.n44 13.5005
R294 VDD_VCO.n46 VDD_VCO.n10 13.5005
R295 VDD_VCO.n48 VDD_VCO.n47 13.5005
R296 VDD_VCO.n50 VDD_VCO.n8 13.5005
R297 VDD_VCO.n53 VDD_VCO.n52 13.5005
R298 VDD_VCO.n54 VDD_VCO.n6 13.5005
R299 VDD_VCO.n56 VDD_VCO.n55 13.5005
R300 VDD_VCO.n58 VDD_VCO.n4 13.5005
R301 VDD_VCO.n61 VDD_VCO.n60 13.5005
R302 VDD_VCO.n62 VDD_VCO.n2 13.5005
R303 VDD_VCO.n64 VDD_VCO.n63 13.5005
R304 VDD_VCO.n88 VDD_VCO.n87 13.5005
R305 VDD_VCO.n103 VDD_VCO.n102 10.607
R306 VDD_VCO.n83 VDD_VCO.n82 10.0805
R307 VDD_VCO.n74 VDD_VCO.t82 9.7717
R308 VDD_VCO.n66 VDD_VCO.t65 9.7717
R309 VDD_VCO VDD_VCO.n103 9.13868
R310 VDD_VCO.n84 VDD_VCO.n0 9.0005
R311 VDD_VCO.n74 VDD_VCO.t81 8.1607
R312 VDD_VCO.n75 VDD_VCO.t80 8.1607
R313 VDD_VCO.n76 VDD_VCO.t79 8.1607
R314 VDD_VCO.n77 VDD_VCO.t78 8.1607
R315 VDD_VCO.n78 VDD_VCO.t77 8.1607
R316 VDD_VCO.n79 VDD_VCO.t76 8.1607
R317 VDD_VCO.n80 VDD_VCO.t75 8.1607
R318 VDD_VCO.n81 VDD_VCO.t74 8.1607
R319 VDD_VCO.n73 VDD_VCO.t73 8.1607
R320 VDD_VCO.n72 VDD_VCO.t72 8.1607
R321 VDD_VCO.n71 VDD_VCO.t71 8.1607
R322 VDD_VCO.n70 VDD_VCO.t70 8.1607
R323 VDD_VCO.n69 VDD_VCO.t69 8.1607
R324 VDD_VCO.n68 VDD_VCO.t68 8.1607
R325 VDD_VCO.n67 VDD_VCO.t67 8.1607
R326 VDD_VCO.n66 VDD_VCO.t66 8.1607
R327 VDD_VCO.n101 VDD_VCO.t42 7.09425
R328 VDD_VCO.n90 VDD_VCO.t45 7.07775
R329 VDD_VCO.n23 VDD_VCO.n20 6.74396
R330 VDD_VCO.n92 VDD_VCO.t30 6.72214
R331 VDD_VCO.n98 VDD_VCO.t64 6.70061
R332 VDD_VCO.n91 VDD_VCO.t24 6.59132
R333 VDD_VCO.n98 VDD_VCO.t57 6.56561
R334 VDD_VCO.n92 VDD_VCO.t61 6.54407
R335 VDD_VCO.n102 VDD_VCO.t36 6.5205
R336 VDD_VCO.n93 VDD_VCO.n91 6.46218
R337 VDD_VCO.n23 VDD_VCO.n22 5.75587
R338 VDD_VCO.n87 VDD_VCO.n86 5.5773
R339 VDD_VCO.n85 VDD_VCO.n65 5.5773
R340 VDD_VCO.n64 VDD_VCO.n3 5.5773
R341 VDD_VCO.n2 VDD_VCO.n1 5.5773
R342 VDD_VCO.n60 VDD_VCO.n59 5.5773
R343 VDD_VCO.n58 VDD_VCO.n57 5.5773
R344 VDD_VCO.n56 VDD_VCO.n7 5.5773
R345 VDD_VCO.n6 VDD_VCO.n5 5.5773
R346 VDD_VCO.n52 VDD_VCO.n51 5.5773
R347 VDD_VCO.n50 VDD_VCO.n49 5.5773
R348 VDD_VCO.n48 VDD_VCO.n11 5.5773
R349 VDD_VCO.n10 VDD_VCO.n9 5.5773
R350 VDD_VCO.n44 VDD_VCO.n43 5.5773
R351 VDD_VCO.n42 VDD_VCO.n41 5.5773
R352 VDD_VCO.n40 VDD_VCO.n15 5.5773
R353 VDD_VCO.n14 VDD_VCO.n13 5.5773
R354 VDD_VCO.n36 VDD_VCO.n35 5.5773
R355 VDD_VCO.n34 VDD_VCO.n33 5.5773
R356 VDD_VCO.n32 VDD_VCO.n19 5.5773
R357 VDD_VCO.n18 VDD_VCO.n17 5.5773
R358 VDD_VCO.n28 VDD_VCO.n27 5.5773
R359 VDD_VCO.n26 VDD_VCO.n25 5.5773
R360 VDD_VCO.n24 VDD_VCO.n21 5.5773
R361 VDD_VCO.n97 VDD_VCO.n93 5.108
R362 VDD_VCO.n99 VDD_VCO.n97 5.063
R363 VDD_VCO.n103 VDD_VCO.n99 4.91675
R364 VDD_VCO.n85 VDD_VCO.n84 4.5005
R365 VDD_VCO.n93 VDD_VCO.n92 4.5005
R366 VDD_VCO.n99 VDD_VCO.n98 4.5005
R367 VDD_VCO.n67 VDD_VCO.n66 1.6115
R368 VDD_VCO.n68 VDD_VCO.n67 1.6115
R369 VDD_VCO.n69 VDD_VCO.n68 1.6115
R370 VDD_VCO.n70 VDD_VCO.n69 1.6115
R371 VDD_VCO.n71 VDD_VCO.n70 1.6115
R372 VDD_VCO.n72 VDD_VCO.n71 1.6115
R373 VDD_VCO.n73 VDD_VCO.n72 1.6115
R374 VDD_VCO.n81 VDD_VCO.n80 1.6115
R375 VDD_VCO.n80 VDD_VCO.n79 1.6115
R376 VDD_VCO.n79 VDD_VCO.n78 1.6115
R377 VDD_VCO.n78 VDD_VCO.n77 1.6115
R378 VDD_VCO.n77 VDD_VCO.n76 1.6115
R379 VDD_VCO.n76 VDD_VCO.n75 1.6115
R380 VDD_VCO.n75 VDD_VCO.n74 1.6115
R381 VDD_VCO VDD_VCO.n88 1.20493
R382 VDD_VCO.n82 VDD_VCO.n81 0.84425
R383 VDD_VCO.n82 VDD_VCO.n73 0.76775
R384 VDD_VCO.n102 VDD_VCO.n101 0.572
R385 VDD_VCO.n86 VDD_VCO.t17 0.4555
R386 VDD_VCO.n86 VDD_VCO.t3 0.4555
R387 VDD_VCO.n65 VDD_VCO.t58 0.4555
R388 VDD_VCO.n65 VDD_VCO.t34 0.4555
R389 VDD_VCO.n3 VDD_VCO.t49 0.4555
R390 VDD_VCO.n3 VDD_VCO.t59 0.4555
R391 VDD_VCO.n1 VDD_VCO.t2 0.4555
R392 VDD_VCO.n1 VDD_VCO.t26 0.4555
R393 VDD_VCO.n59 VDD_VCO.t5 0.4555
R394 VDD_VCO.n59 VDD_VCO.t4 0.4555
R395 VDD_VCO.n57 VDD_VCO.t11 0.4555
R396 VDD_VCO.n57 VDD_VCO.t27 0.4555
R397 VDD_VCO.n7 VDD_VCO.t1 0.4555
R398 VDD_VCO.n7 VDD_VCO.t0 0.4555
R399 VDD_VCO.n5 VDD_VCO.t33 0.4555
R400 VDD_VCO.n5 VDD_VCO.t16 0.4555
R401 VDD_VCO.n51 VDD_VCO.t53 0.4555
R402 VDD_VCO.n51 VDD_VCO.t52 0.4555
R403 VDD_VCO.n49 VDD_VCO.t19 0.4555
R404 VDD_VCO.n49 VDD_VCO.t14 0.4555
R405 VDD_VCO.n11 VDD_VCO.t22 0.4555
R406 VDD_VCO.n11 VDD_VCO.t21 0.4555
R407 VDD_VCO.n9 VDD_VCO.t28 0.4555
R408 VDD_VCO.n9 VDD_VCO.t37 0.4555
R409 VDD_VCO.n43 VDD_VCO.t43 0.4555
R410 VDD_VCO.n43 VDD_VCO.t62 0.4555
R411 VDD_VCO.n41 VDD_VCO.t10 0.4555
R412 VDD_VCO.n41 VDD_VCO.t9 0.4555
R413 VDD_VCO.n15 VDD_VCO.t54 0.4555
R414 VDD_VCO.n15 VDD_VCO.t20 0.4555
R415 VDD_VCO.n13 VDD_VCO.t32 0.4555
R416 VDD_VCO.n13 VDD_VCO.t55 0.4555
R417 VDD_VCO.n35 VDD_VCO.t47 0.4555
R418 VDD_VCO.n35 VDD_VCO.t46 0.4555
R419 VDD_VCO.n33 VDD_VCO.t48 0.4555
R420 VDD_VCO.n33 VDD_VCO.t15 0.4555
R421 VDD_VCO.n19 VDD_VCO.t40 0.4555
R422 VDD_VCO.n19 VDD_VCO.t18 0.4555
R423 VDD_VCO.n17 VDD_VCO.t6 0.4555
R424 VDD_VCO.n17 VDD_VCO.t31 0.4555
R425 VDD_VCO.n27 VDD_VCO.t12 0.4555
R426 VDD_VCO.n27 VDD_VCO.t8 0.4555
R427 VDD_VCO.n25 VDD_VCO.t51 0.4555
R428 VDD_VCO.n25 VDD_VCO.t13 0.4555
R429 VDD_VCO.n21 VDD_VCO.t39 0.4555
R430 VDD_VCO.n21 VDD_VCO.t38 0.4555
R431 VDD_VCO.n22 VDD_VCO.t7 0.4555
R432 VDD_VCO.n22 VDD_VCO.t50 0.4555
R433 VDD_VCO.n91 VDD_VCO.n90 0.450758
R434 VDD_VCO.n26 VDD_VCO.n24 0.3605
R435 VDD_VCO.n28 VDD_VCO.n26 0.3605
R436 VDD_VCO.n28 VDD_VCO.n18 0.3605
R437 VDD_VCO.n32 VDD_VCO.n18 0.3605
R438 VDD_VCO.n34 VDD_VCO.n32 0.3605
R439 VDD_VCO.n36 VDD_VCO.n34 0.3605
R440 VDD_VCO.n36 VDD_VCO.n14 0.3605
R441 VDD_VCO.n40 VDD_VCO.n14 0.3605
R442 VDD_VCO.n42 VDD_VCO.n40 0.3605
R443 VDD_VCO.n44 VDD_VCO.n42 0.3605
R444 VDD_VCO.n44 VDD_VCO.n10 0.3605
R445 VDD_VCO.n48 VDD_VCO.n10 0.3605
R446 VDD_VCO.n50 VDD_VCO.n48 0.3605
R447 VDD_VCO.n52 VDD_VCO.n50 0.3605
R448 VDD_VCO.n52 VDD_VCO.n6 0.3605
R449 VDD_VCO.n56 VDD_VCO.n6 0.3605
R450 VDD_VCO.n58 VDD_VCO.n56 0.3605
R451 VDD_VCO.n60 VDD_VCO.n58 0.3605
R452 VDD_VCO.n60 VDD_VCO.n2 0.3605
R453 VDD_VCO.n64 VDD_VCO.n2 0.3605
R454 VDD_VCO.n85 VDD_VCO.n64 0.3605
R455 VDD_VCO.n87 VDD_VCO.n85 0.3605
R456 VDD_VCO.n24 VDD_VCO.n23 0.178208
R457 VDD_VCO.n29 VDD_VCO.n20 0.0659545
R458 VDD_VCO.n30 VDD_VCO.n29 0.0659545
R459 VDD_VCO.n31 VDD_VCO.n30 0.0659545
R460 VDD_VCO.n31 VDD_VCO.n16 0.0659545
R461 VDD_VCO.n37 VDD_VCO.n16 0.0659545
R462 VDD_VCO.n38 VDD_VCO.n37 0.0659545
R463 VDD_VCO.n39 VDD_VCO.n38 0.0659545
R464 VDD_VCO.n39 VDD_VCO.n12 0.0659545
R465 VDD_VCO.n45 VDD_VCO.n12 0.0659545
R466 VDD_VCO.n46 VDD_VCO.n45 0.0659545
R467 VDD_VCO.n47 VDD_VCO.n46 0.0659545
R468 VDD_VCO.n47 VDD_VCO.n8 0.0659545
R469 VDD_VCO.n53 VDD_VCO.n8 0.0659545
R470 VDD_VCO.n54 VDD_VCO.n53 0.0659545
R471 VDD_VCO.n55 VDD_VCO.n54 0.0659545
R472 VDD_VCO.n55 VDD_VCO.n4 0.0659545
R473 VDD_VCO.n61 VDD_VCO.n4 0.0659545
R474 VDD_VCO.n62 VDD_VCO.n61 0.0659545
R475 VDD_VCO.n63 VDD_VCO.n62 0.0659545
R476 VDD_VCO.n63 VDD_VCO.n0 0.0659545
R477 VDD_VCO.n88 VDD_VCO.n0 0.0659545
R478 VDD.n6 VDD.t90 1778.9
R479 VDD.t139 VDD.t136 1379.31
R480 VDD.n211 VDD.t156 830.979
R481 VDD.n57 VDD.t162 415
R482 VDD.n57 VDD.t31 415
R483 VDD.n38 VDD.t158 415
R484 VDD.n30 VDD.t154 415
R485 VDD.n233 VDD.n228 412.089
R486 VDD.n234 VDD.n233 412.089
R487 VDD.n235 VDD.n226 412.089
R488 VDD.n239 VDD.n226 412.089
R489 VDD.n240 VDD.n239 412.089
R490 VDD.t102 VDD.n228 402.474
R491 VDD.t174 VDD.t26 400
R492 VDD.t29 VDD.t61 400
R493 VDD.n257 VDD.n256 354.611
R494 VDD.n535 VDD.n257 354.611
R495 VDD.n535 VDD.n534 354.611
R496 VDD.n533 VDD.n259 354.611
R497 VDD.n529 VDD.n259 354.611
R498 VDD.n529 VDD.n528 354.611
R499 VDD.n527 VDD.n261 354.611
R500 VDD.n262 VDD.n261 354.611
R501 VDD.n269 VDD.n262 354.611
R502 VDD.n270 VDD.n269 354.611
R503 VDD.n519 VDD.n271 354.611
R504 VDD.n519 VDD.n518 354.611
R505 VDD.n518 VDD.n517 354.611
R506 VDD.n517 VDD.n273 354.611
R507 VDD.n278 VDD.n277 354.611
R508 VDD.n511 VDD.n278 354.611
R509 VDD.n511 VDD.n510 354.611
R510 VDD.n506 VDD.n505 354.611
R511 VDD.n505 VDD.n504 354.611
R512 VDD.n504 VDD.n281 354.611
R513 VDD.n288 VDD.n287 354.611
R514 VDD.n292 VDD.n288 354.611
R515 VDD.n292 VDD.n291 354.611
R516 VDD.n528 VDD.t80 350.178
R517 VDD.n9 VDD.n6 324.796
R518 VDD.n510 VDD.t118 321.81
R519 VDD.t104 VDD.n25 312.122
R520 VDD.n31 VDD.n30 312.122
R521 VDD.t215 VDD.n240 292.582
R522 VDD.n99 VDD.n96 285.714
R523 VDD.n110 VDD.n96 285.714
R524 VDD.n112 VDD.n110 285.714
R525 VDD.n112 VDD.n111 285.714
R526 VDD.n123 VDD.n122 285.714
R527 VDD.n123 VDD.n89 285.714
R528 VDD.n134 VDD.n89 285.714
R529 VDD.n135 VDD.n134 285.714
R530 VDD.n144 VDD.n85 285.714
R531 VDD.n145 VDD.n144 285.714
R532 VDD.n154 VDD.n79 285.714
R533 VDD.n155 VDD.n154 285.714
R534 VDD.n167 VDD.n166 285.714
R535 VDD.n203 VDD.n173 285.714
R536 VDD.n122 VDD.t189 277.144
R537 VDD.n534 VDD.t196 272.163
R538 VDD.n166 VDD.t2 267.144
R539 VDD.n41 VDD.t98 258.654
R540 VDD.n291 VDD.t116 257.979
R541 VDD.t153 VDD.n234 254.121
R542 VDD.n39 VDD.n38 253.03
R543 VDD.n506 VDD.t65 252.661
R544 VDD.t68 VDD.n85 251.429
R545 VDD.t147 VDD.t67 224.839
R546 VDD.n167 VDD.t57 212.857
R547 VDD.n99 VDD.t114 210
R548 VDD.n56 VDD.n54 198.537
R549 VDD.n57 VDD.t174 190
R550 VDD.n23 VDD.t29 190
R551 VDD.t176 VDD.n203 187.143
R552 VDD.t160 VDD.n281 179.965
R553 VDD.t64 VDD.t78 179.078
R554 VDD.t42 VDD.t130 179.078
R555 VDD.n287 VDD.t160 174.645
R556 VDD.n6 VDD.t139 168.357
R557 VDD.n256 VDD.t207 160.462
R558 VDD.n235 VDD.t153 157.968
R559 VDD.n23 VDD.n22 156.061
R560 VDD.n37 VDD.t41 156.061
R561 VDD.n145 VDD.t55 147.143
R562 VDD.t207 VDD.t145 134.752
R563 VDD.n277 VDD.t42 132.98
R564 VDD.n241 VDD.t215 131.724
R565 VDD.t55 VDD.t84 114.287
R566 VDD.t51 VDD.t49 114.287
R567 VDD.t39 VDD.t143 114.287
R568 VDD.t37 VDD.t39 114.287
R569 VDD.t166 VDD.t86 114.287
R570 VDD.t164 VDD.t166 114.287
R571 VDD.t124 VDD.t122 114.287
R572 VDD.t200 VDD.t120 114.287
R573 VDD.t198 VDD.t200 114.287
R574 VDD.t122 VDD.n194 112.858
R575 VDD.t116 VDD.n290 109.231
R576 VDD.n59 VDD.n57 108.674
R577 VDD.n509 VDD.t65 101.951
R578 VDD.n39 VDD.t178 101.359
R579 VDD.n204 VDD.t176 98.5719
R580 VDD.n29 VDD.n27 96.9702
R581 VDD.n39 VDD.n18 96.8074
R582 VDD.n241 VDD.t141 96.1758
R583 VDD.t78 VDD.n270 95.7452
R584 VDD.n156 VDD.t51 95.7148
R585 VDD.t185 VDD.t16 94.3401
R586 VDD.t133 VDD.t185 94.3401
R587 VDD.t131 VDD.t133 94.3401
R588 VDD.t35 VDD.t187 94.3401
R589 VDD.t33 VDD.t35 94.3401
R590 VDD.t18 VDD.t33 94.3401
R591 VDD.t106 VDD.t14 94.3401
R592 VDD.t149 VDD.t106 94.3401
R593 VDD.t59 VDD.t149 94.3401
R594 VDD.t181 VDD.t45 94.3401
R595 VDD.t45 VDD.t172 94.3401
R596 VDD.t172 VDD.t170 94.3401
R597 VDD.t204 VDD.t108 94.3401
R598 VDD.t202 VDD.t204 94.3401
R599 VDD.t72 VDD.t202 94.3401
R600 VDD.t20 VDD.t22 94.3401
R601 VDD.t168 VDD.t20 94.3401
R602 VDD.t213 VDD.t168 94.3401
R603 VDD.t92 VDD.t128 94.3401
R604 VDD.t128 VDD.t76 94.3401
R605 VDD.t76 VDD.t74 94.3401
R606 VDD.t43 VDD.t70 94.3401
R607 VDD.t194 VDD.t43 94.3401
R608 VDD.t192 VDD.t194 94.3401
R609 VDD.t47 VDD.t112 94.3401
R610 VDD.t4 VDD.t47 94.3401
R611 VDD.t0 VDD.t4 94.3401
R612 VDD.t24 VDD.t88 94.3401
R613 VDD.t88 VDD.t12 94.3401
R614 VDD.t12 VDD.t10 94.3401
R615 VDD.t82 VDD.t6 94.3401
R616 VDD.t183 VDD.t82 94.3401
R617 VDD.t211 VDD.t183 94.3401
R618 VDD.t126 VDD.t209 94.3401
R619 VDD.t53 VDD.t126 94.3401
R620 VDD.t8 VDD.t53 94.3401
R621 VDD.t114 VDD.n98 88.3148
R622 VDD.t196 VDD.n533 82.4473
R623 VDD.t191 VDD.t147 82.2996
R624 VDD.n271 VDD.t64 79.7877
R625 VDD.t110 VDD.t191 75.768
R626 VDD.t49 VDD.n155 75.7148
R627 VDD.t145 VDD.n255 72.8977
R628 VDD.n172 VDD.t57 72.8576
R629 VDD.n39 VDD.t27 69.2421
R630 VDD.n188 VDD.t198 68.3148
R631 VDD.n43 VDD.n39 58.7856
R632 VDD.n483 VDD.t8 58.5911
R633 VDD.n195 VDD.t124 58.5719
R634 VDD.n195 VDD.t164 55.7148
R635 VDD.t187 VDD.n466 48.3496
R636 VDD.t14 VDD.n467 48.3496
R637 VDD.n468 VDD.t181 48.3496
R638 VDD.t108 VDD.n471 48.3496
R639 VDD.t22 VDD.n472 48.3496
R640 VDD.n473 VDD.t92 48.3496
R641 VDD.t70 VDD.n476 48.3496
R642 VDD.t112 VDD.n477 48.3496
R643 VDD.n478 VDD.t24 48.3496
R644 VDD.t6 VDD.n481 48.3496
R645 VDD.t209 VDD.n482 48.3496
R646 VDD.t178 VDD.t100 47.0224
R647 VDD.n39 VDD.n14 47.0224
R648 VDD.n466 VDD.t131 45.9911
R649 VDD.n467 VDD.t18 45.9911
R650 VDD.n468 VDD.t59 45.9911
R651 VDD.n471 VDD.t170 45.9911
R652 VDD.n472 VDD.t72 45.9911
R653 VDD.n473 VDD.t213 45.9911
R654 VDD.n476 VDD.t74 45.9911
R655 VDD.n477 VDD.t192 45.9911
R656 VDD.n478 VDD.t0 45.9911
R657 VDD.n481 VDD.t10 45.9911
R658 VDD.n482 VDD.t211 45.9911
R659 VDD.t96 VDD.t94 45.7222
R660 VDD.n18 VDD.t96 44.9112
R661 VDD.t130 VDD.n273 42.5537
R662 VDD.t143 VDD.n172 41.4291
R663 VDD.n25 VDD.n23 39.3944
R664 VDD.n31 VDD.t41 39.3944
R665 VDD.t100 VDD.t95 36.5731
R666 VDD.n135 VDD.t68 34.2862
R667 VDD.t98 VDD.t110 33.9652
R668 VDD.t118 VDD.n509 32.8019
R669 VDD.n47 VDD.t148 26.9179
R670 VDD.n298 VDD.t135 25.583
R671 VDD.n297 VDD.t138 25.583
R672 VDD.n501 VDD.n500 24.836
R673 VDD.t84 VDD.n79 24.2862
R674 VDD.n48 VDD.t99 22.7981
R675 VDD.n214 VDD.n9 22.7428
R676 VDD.n22 VDD.t151 22.7278
R677 VDD.n38 VDD.n37 22.7278
R678 VDD.n230 VDD.t102 22.2159
R679 VDD.n244 VDD.t216 19.7374
R680 VDD.n46 VDD.t111 18.7805
R681 VDD.n156 VDD.t2 18.5719
R682 VDD.n266 VDD.t81 17.6066
R683 VDD.n285 VDD.t117 17.5819
R684 VDD.n538 VDD.n254 17.5505
R685 VDD.n264 VDD.t197 17.3996
R686 VDD.n296 VDD.t161 17.2849
R687 VDD.n211 VDD.t157 17.1088
R688 VDD.n229 VDD.t103 16.0233
R689 VDD.n245 VDD.t142 16.0143
R690 VDD.n204 VDD.t37 15.7148
R691 VDD.n230 VDD.n229 14.5243
R692 VDD.n299 VDD.n298 14.468
R693 VDD.n243 VDD.n242 14.0518
R694 VDD.n236 VDD.n224 14.0518
R695 VDD.n290 VDD.n285 13.64
R696 VDD.n295 VDD.n294 13.64
R697 VDD.n503 VDD.n502 13.64
R698 VDD.n508 VDD.n275 13.64
R699 VDD.n514 VDD.n513 13.64
R700 VDD.n516 VDD.n515 13.64
R701 VDD.n522 VDD.n521 13.64
R702 VDD.n524 VDD.n523 13.64
R703 VDD.n265 VDD.n260 13.64
R704 VDD.n532 VDD.n253 13.64
R705 VDD.n190 VDD.n187 13.6198
R706 VDD.n104 VDD.n101 13.613
R707 VDD.n105 VDD.n97 13.5005
R708 VDD.n108 VDD.n107 13.5005
R709 VDD.n106 VDD.n95 13.5005
R710 VDD.n114 VDD.n94 13.5005
R711 VDD.n117 VDD.n116 13.5005
R712 VDD.n120 VDD.n119 13.5005
R713 VDD.n118 VDD.n92 13.5005
R714 VDD.n125 VDD.n91 13.5005
R715 VDD.n128 VDD.n127 13.5005
R716 VDD.n129 VDD.n90 13.5005
R717 VDD.n131 VDD.n130 13.5005
R718 VDD.n132 VDD.n87 13.5005
R719 VDD.n139 VDD.n138 13.5005
R720 VDD.n140 VDD.n86 13.5005
R721 VDD.n142 VDD.n141 13.5005
R722 VDD.n84 VDD.n83 13.5005
R723 VDD.n150 VDD.n149 13.5005
R724 VDD.n152 VDD.n151 13.5005
R725 VDD.n82 VDD.n76 13.5005
R726 VDD.n160 VDD.n159 13.5005
R727 VDD.n161 VDD.n75 13.5005
R728 VDD.n164 VDD.n163 13.5005
R729 VDD.n162 VDD.n74 13.5005
R730 VDD.n169 VDD.n68 13.5005
R731 VDD.n208 VDD.n207 13.5005
R732 VDD.n206 VDD.n69 13.5005
R733 VDD.n176 VDD.n174 13.5005
R734 VDD.n201 VDD.n200 13.5005
R735 VDD.n199 VDD.n198 13.5005
R736 VDD.n180 VDD.n177 13.5005
R737 VDD.n186 VDD.n183 13.5005
R738 VDD.n192 VDD.n191 13.5005
R739 VDD.n190 VDD.n189 13.5005
R740 VDD.n104 VDD.n103 13.5005
R741 VDD.n466 VDD.n465 13.3205
R742 VDD.n231 VDD.n228 12.6005
R743 VDD.n233 VDD.n232 12.6005
R744 VDD.n234 VDD.n227 12.6005
R745 VDD.n236 VDD.n235 12.6005
R746 VDD.n237 VDD.n226 12.6005
R747 VDD.n239 VDD.n238 12.6005
R748 VDD.n240 VDD.n225 12.6005
R749 VDD.n41 VDD.n40 12.6005
R750 VDD.n56 VDD.n55 12.6005
R751 VDD.n54 VDD.n53 12.6005
R752 VDD.n29 VDD.n28 12.6005
R753 VDD.n27 VDD.n26 12.6005
R754 VDD.n194 VDD.n193 12.6005
R755 VDD.n196 VDD.n195 12.6005
R756 VDD.n178 VDD.n173 12.6005
R757 VDD.n203 VDD.n202 12.6005
R758 VDD.n205 VDD.n204 12.6005
R759 VDD.n172 VDD.n171 12.6005
R760 VDD.n168 VDD.n167 12.6005
R761 VDD.n166 VDD.n165 12.6005
R762 VDD.n157 VDD.n156 12.6005
R763 VDD.n155 VDD.n77 12.6005
R764 VDD.n154 VDD.n153 12.6005
R765 VDD.n148 VDD.n79 12.6005
R766 VDD.n146 VDD.n145 12.6005
R767 VDD.n144 VDD.n143 12.6005
R768 VDD.n137 VDD.n85 12.6005
R769 VDD.n136 VDD.n135 12.6005
R770 VDD.n134 VDD.n133 12.6005
R771 VDD.n126 VDD.n89 12.6005
R772 VDD.n124 VDD.n123 12.6005
R773 VDD.n122 VDD.n121 12.6005
R774 VDD.n111 VDD.n93 12.6005
R775 VDD.n113 VDD.n112 12.6005
R776 VDD.n110 VDD.n109 12.6005
R777 VDD.n102 VDD.n96 12.6005
R778 VDD.n100 VDD.n99 12.6005
R779 VDD.n256 VDD.n255 12.6005
R780 VDD.n537 VDD.n257 12.6005
R781 VDD.n536 VDD.n535 12.6005
R782 VDD.n534 VDD.n258 12.6005
R783 VDD.n533 VDD.n532 12.6005
R784 VDD.n531 VDD.n259 12.6005
R785 VDD.n530 VDD.n529 12.6005
R786 VDD.n528 VDD.n260 12.6005
R787 VDD.n527 VDD.n526 12.6005
R788 VDD.n525 VDD.n261 12.6005
R789 VDD.n524 VDD.n262 12.6005
R790 VDD.n269 VDD.n263 12.6005
R791 VDD.n270 VDD.n268 12.6005
R792 VDD.n521 VDD.n271 12.6005
R793 VDD.n520 VDD.n519 12.6005
R794 VDD.n518 VDD.n272 12.6005
R795 VDD.n517 VDD.n516 12.6005
R796 VDD.n274 VDD.n273 12.6005
R797 VDD.n277 VDD.n276 12.6005
R798 VDD.n513 VDD.n278 12.6005
R799 VDD.n512 VDD.n511 12.6005
R800 VDD.n510 VDD.n279 12.6005
R801 VDD.n509 VDD.n508 12.6005
R802 VDD.n507 VDD.n506 12.6005
R803 VDD.n505 VDD.n280 12.6005
R804 VDD.n504 VDD.n503 12.6005
R805 VDD.n282 VDD.n281 12.6005
R806 VDD.n287 VDD.n286 12.6005
R807 VDD.n294 VDD.n288 12.6005
R808 VDD.n293 VDD.n292 12.6005
R809 VDD.n291 VDD.n289 12.6005
R810 VDD.n467 VDD.n465 12.6005
R811 VDD.n469 VDD.n468 12.6005
R812 VDD.n471 VDD.n470 12.6005
R813 VDD.n472 VDD.n464 12.6005
R814 VDD.n474 VDD.n473 12.6005
R815 VDD.n476 VDD.n475 12.6005
R816 VDD.n477 VDD.n463 12.6005
R817 VDD.n479 VDD.n478 12.6005
R818 VDD.n481 VDD.n480 12.6005
R819 VDD.n482 VDD.n462 12.6005
R820 VDD.n458 VDD.n457 11.2807
R821 VDD.n383 VDD.n358 11.264
R822 VDD.n385 VDD.n365 11.264
R823 VDD.n387 VDD.n371 11.264
R824 VDD.n389 VDD.n377 11.264
R825 VDD.n397 VDD.n338 11.264
R826 VDD.n429 VDD.n428 11.264
R827 VDD.n433 VDD.n337 11.264
R828 VDD.n431 VDD.n331 11.264
R829 VDD.n325 VDD.n322 11.264
R830 VDD.n454 VDD.n453 11.264
R831 VDD.n382 VDD.n354 11.264
R832 VDD.n384 VDD.n359 11.264
R833 VDD.n386 VDD.n368 11.264
R834 VDD.n388 VDD.n374 11.264
R835 VDD.n391 VDD.n390 11.264
R836 VDD.n425 VDD.n424 11.264
R837 VDD.n435 VDD.n434 11.264
R838 VDD.n432 VDD.n334 11.264
R839 VDD.n430 VDD.n328 11.264
R840 VDD.n450 VDD.n449 11.264
R841 VDD.n459 VDD.n458 11.264
R842 VDD.n381 VDD.n380 11.264
R843 VDD.n284 VDD.n283 11.174
R844 VDD.n541 VDD.n540 11.1695
R845 VDD.n267 VDD.n254 10.8005
R846 VDD.n247 VDD.n246 10.0222
R847 VDD.n210 VDD.n209 10.0046
R848 VDD.n212 VDD.n211 9.64463
R849 VDD.n246 VDD.n223 9.59352
R850 VDD.n18 VDD.t62 9.47894
R851 VDD.n65 VDD.n62 9.35573
R852 VDD.n34 VDD.n33 9.26036
R853 VDD.n246 VDD.n245 9.20362
R854 VDD.n538 VDD.n537 9.14
R855 VDD.n35 VDD.n34 9.1223
R856 VDD.n46 VDD.n45 9.1203
R857 VDD.n51 VDD.n49 9.11468
R858 VDD.n62 VDD.n61 9.0323
R859 VDD.n210 VDD.n67 9.022
R860 VDD.n111 VDD.t189 8.57193
R861 VDD.n298 VDD.n297 6.7505
R862 VDD.n540 VDD.t146 6.725
R863 VDD.n283 VDD.t119 6.61536
R864 VDD.n212 VDD.n210 6.53312
R865 VDD VDD.n541 6.41359
R866 VDD.n283 VDD.t66 6.16086
R867 VDD.n540 VDD.t208 6.1085
R868 VDD.n16 VDD.t28 6.03129
R869 VDD.n252 VDD.n251 5.5205
R870 VDD.n26 VDD.t105 5.4265
R871 VDD.n28 VDD.t155 5.4265
R872 VDD.n40 VDD.t97 5.4265
R873 VDD.n53 VDD.t101 5.4265
R874 VDD.n55 VDD.t32 5.4265
R875 VDD.n21 VDD.t152 5.422
R876 VDD.n36 VDD.t159 5.422
R877 VDD.n42 VDD.t180 5.422
R878 VDD.n15 VDD.t206 5.422
R879 VDD.n60 VDD.t163 5.422
R880 VDD.n32 VDD.t79 5.3545
R881 VDD.n44 VDD.t63 5.3545
R882 VDD.n50 VDD.t179 5.3545
R883 VDD.n58 VDD.t175 5.3545
R884 VDD.n24 VDD.t30 5.3545
R885 VDD.n411 VDD.n350 4.8365
R886 VDD.n487 VDD.n316 4.8365
R887 VDD.n457 VDD.n456 4.54556
R888 VDD.n358 VDD.n357 4.54556
R889 VDD.n365 VDD.n364 4.54556
R890 VDD.n371 VDD.n370 4.54556
R891 VDD.n377 VDD.n376 4.54556
R892 VDD.n397 VDD.n396 4.54556
R893 VDD.n428 VDD.n427 4.54556
R894 VDD.n337 VDD.n336 4.54556
R895 VDD.n331 VDD.n330 4.54556
R896 VDD.n325 VDD.n324 4.54556
R897 VDD.n453 VDD.n452 4.54556
R898 VDD.n354 VDD.n353 4.54556
R899 VDD.n361 VDD.n359 4.54556
R900 VDD.n368 VDD.n367 4.54556
R901 VDD.n374 VDD.n373 4.54556
R902 VDD.n393 VDD.n391 4.54556
R903 VDD.n424 VDD.n423 4.54556
R904 VDD.n437 VDD.n435 4.54556
R905 VDD.n334 VDD.n333 4.54556
R906 VDD.n328 VDD.n327 4.54556
R907 VDD.n449 VDD.n448 4.54556
R908 VDD.n459 VDD.n319 4.54556
R909 VDD.n380 VDD.n379 4.54556
R910 VDD.n249 VDD.n2 4.5155
R911 VDD.n26 VDD.n20 4.5005
R912 VDD.n40 VDD.n17 4.5005
R913 VDD.n53 VDD.n52 4.5005
R914 VDD.n55 VDD.n13 4.5005
R915 VDD.n28 VDD.n19 4.5005
R916 VDD.n63 VDD.n11 4.5005
R917 VDD.n65 VDD.n63 4.5005
R918 VDD.n64 VDD.n10 4.5005
R919 VDD.n66 VDD.n11 4.5005
R920 VDD.n66 VDD.n65 4.5005
R921 VDD.n223 VDD.n3 4.5005
R922 VDD.n223 VDD.n222 4.5005
R923 VDD.n5 VDD.n4 4.5005
R924 VDD.n221 VDD.n3 4.5005
R925 VDD.n222 VDD.n221 4.5005
R926 VDD.n220 VDD.n215 4.5005
R927 VDD.n220 VDD.n219 4.5005
R928 VDD.n217 VDD.n216 4.5005
R929 VDD.n218 VDD.n215 4.5005
R930 VDD.n219 VDD.n218 4.5005
R931 VDD.n248 VDD.n1 4.5005
R932 VDD.n250 VDD.n249 4.5005
R933 VDD.n539 VDD.n538 4.5005
R934 VDD.n487 VDD.n486 4.5005
R935 VDD.n489 VDD.n488 4.5005
R936 VDD.n491 VDD.n309 4.5005
R937 VDD.n494 VDD.n493 4.5005
R938 VDD.n496 VDD.n495 4.5005
R939 VDD.n308 VDD.n305 4.5005
R940 VDD.n420 VDD.n419 4.5005
R941 VDD.n418 VDD.n417 4.5005
R942 VDD.n415 VDD.n343 4.5005
R943 VDD.n413 VDD.n412 4.5005
R944 VDD.n411 VDD.n410 4.5005
R945 VDD.n455 VDD.n321 4.5005
R946 VDD.n378 VDD.n355 4.5005
R947 VDD.n408 VDD.n407 4.5005
R948 VDD.n406 VDD.n351 4.5005
R949 VDD.n405 VDD.n362 4.5005
R950 VDD.n404 VDD.n348 4.5005
R951 VDD.n403 VDD.n347 4.5005
R952 VDD.n402 VDD.n346 4.5005
R953 VDD.n401 VDD.n345 4.5005
R954 VDD.n400 VDD.n344 4.5005
R955 VDD.n399 VDD.n394 4.5005
R956 VDD.n398 VDD.n341 4.5005
R957 VDD.n422 VDD.n339 4.5005
R958 VDD.n304 VDD.n300 4.5005
R959 VDD.n499 VDD.n498 4.5005
R960 VDD.n306 VDD.n301 4.5005
R961 VDD.n439 VDD.n438 4.5005
R962 VDD.n440 VDD.n310 4.5005
R963 VDD.n441 VDD.n311 4.5005
R964 VDD.n442 VDD.n312 4.5005
R965 VDD.n443 VDD.n313 4.5005
R966 VDD.n444 VDD.n314 4.5005
R967 VDD.n447 VDD.n445 4.5005
R968 VDD.n320 VDD.n317 4.5005
R969 VDD.n461 VDD.n460 4.5005
R970 VDD.t80 VDD.n527 4.43312
R971 VDD.n7 VDD.t137 4.31802
R972 VDD.n98 VDD.t115 4.30006
R973 VDD.n43 VDD.n41 3.91951
R974 VDD.n7 VDD.t140 3.20383
R975 VDD.n43 VDD.n42 3.1505
R976 VDD.n44 VDD.n43 3.1505
R977 VDD.n59 VDD.n58 3.1505
R978 VDD.n60 VDD.n59 3.1505
R979 VDD.n15 VDD.n14 3.1505
R980 VDD.n50 VDD.n14 3.1505
R981 VDD.n37 VDD.n36 3.1505
R982 VDD.n22 VDD.n21 3.1505
R983 VDD.n32 VDD.n31 3.1505
R984 VDD.n25 VDD.n24 3.1505
R985 VDD.n54 VDD.n14 3.1353
R986 VDD.n59 VDD.n56 3.1353
R987 VDD.n27 VDD.t104 3.0308
R988 VDD.n30 VDD.n29 3.0308
R989 VDD.n8 VDD.t91 2.88808
R990 VDD.n115 VDD.t190 2.73329
R991 VDD.n243 VDD.n224 2.7005
R992 VDD.n539 VDD.n253 2.7005
R993 VDD.n523 VDD.n522 2.7005
R994 VDD.n515 VDD.n514 2.7005
R995 VDD.n514 VDD.n275 2.7005
R996 VDD.n295 VDD.n285 2.7005
R997 VDD.n265 VDD.n264 2.48675
R998 VDD.n502 VDD.n284 2.3855
R999 VDD.n21 VDD.n20 2.37386
R1000 VDD.n42 VDD.n17 2.37386
R1001 VDD.n52 VDD.n16 2.36968
R1002 VDD.n147 VDD.t56 2.33099
R1003 VDD.n80 VDD.t85 2.33099
R1004 VDD.n515 VDD.n267 2.2505
R1005 VDD.n229 VDD.n224 2.228
R1006 VDD.n247 VDD.n0 2.22139
R1007 VDD.n24 VDD.n19 2.16637
R1008 VDD.n58 VDD.n13 2.16537
R1009 VDD.n245 VDD.n244 2.05925
R1010 VDD.n81 VDD.t50 1.98179
R1011 VDD.n170 VDD.t58 1.94867
R1012 VDD.n88 VDD.t69 1.90049
R1013 VDD.n175 VDD.t87 1.90049
R1014 VDD.n187 VDD.t199 1.90049
R1015 VDD.n456 VDD.t9 1.67257
R1016 VDD.n379 VDD.t17 1.67257
R1017 VDD.n266 VDD.n265 1.51925
R1018 VDD.n33 VDD.n32 1.5016
R1019 VDD.n45 VDD.n44 1.50042
R1020 VDD.n51 VDD.n50 1.50042
R1021 VDD.n36 VDD.n35 1.49976
R1022 VDD.n61 VDD.n60 1.49976
R1023 VDD.t86 VDD.n173 1.42907
R1024 VDD.n194 VDD.t120 1.42907
R1025 VDD.n213 VDD.n66 1.39912
R1026 VDD.n381 VDD.n252 1.35783
R1027 VDD.n158 VDD.n78 1.35157
R1028 VDD.n71 VDD.n70 1.33617
R1029 VDD.n73 VDD.n72 1.33617
R1030 VDD.n197 VDD.n179 1.31249
R1031 VDD.n182 VDD.n181 1.31249
R1032 VDD.n185 VDD.n184 1.31249
R1033 VDD.n297 VDD.n254 1.283
R1034 VDD.n34 VDD.n12 1.238
R1035 VDD.n523 VDD.n266 1.18175
R1036 VDD.n541 VDD.n539 1.1705
R1037 VDD.n502 VDD.n501 1.1705
R1038 VDD.n304 VDD.n303 1.0773
R1039 VDD.n498 VDD.n302 1.0773
R1040 VDD.n296 VDD.n295 1.0355
R1041 VDD.n357 VDD.n356 0.937568
R1042 VDD.n364 VDD.n363 0.937568
R1043 VDD.n370 VDD.n369 0.937568
R1044 VDD.n376 VDD.n375 0.937568
R1045 VDD.n396 VDD.n395 0.937568
R1046 VDD.n427 VDD.n426 0.937568
R1047 VDD.n336 VDD.n335 0.937568
R1048 VDD.n330 VDD.n329 0.937568
R1049 VDD.n324 VDD.n323 0.937568
R1050 VDD.n452 VDD.n451 0.937568
R1051 VDD.n353 VDD.n352 0.937568
R1052 VDD.n361 VDD.n360 0.937568
R1053 VDD.n367 VDD.n366 0.937568
R1054 VDD.n373 VDD.n372 0.937568
R1055 VDD.n393 VDD.n392 0.937568
R1056 VDD.n423 VDD.n340 0.937568
R1057 VDD.n437 VDD.n436 0.937568
R1058 VDD.n333 VDD.n332 0.937568
R1059 VDD.n327 VDD.n326 0.937568
R1060 VDD.n448 VDD.n446 0.937568
R1061 VDD.n319 VDD.n318 0.937568
R1062 VDD.n537 VDD.n255 0.9005
R1063 VDD.n537 VDD.n536 0.9005
R1064 VDD.n536 VDD.n258 0.9005
R1065 VDD.n532 VDD.n258 0.9005
R1066 VDD.n532 VDD.n531 0.9005
R1067 VDD.n531 VDD.n530 0.9005
R1068 VDD.n530 VDD.n260 0.9005
R1069 VDD.n526 VDD.n260 0.9005
R1070 VDD.n526 VDD.n525 0.9005
R1071 VDD.n525 VDD.n524 0.9005
R1072 VDD.n524 VDD.n263 0.9005
R1073 VDD.n268 VDD.n263 0.9005
R1074 VDD.n521 VDD.n268 0.9005
R1075 VDD.n521 VDD.n520 0.9005
R1076 VDD.n520 VDD.n272 0.9005
R1077 VDD.n516 VDD.n272 0.9005
R1078 VDD.n516 VDD.n274 0.9005
R1079 VDD.n276 VDD.n274 0.9005
R1080 VDD.n513 VDD.n276 0.9005
R1081 VDD.n513 VDD.n512 0.9005
R1082 VDD.n512 VDD.n279 0.9005
R1083 VDD.n508 VDD.n279 0.9005
R1084 VDD.n508 VDD.n507 0.9005
R1085 VDD.n507 VDD.n280 0.9005
R1086 VDD.n503 VDD.n280 0.9005
R1087 VDD.n503 VDD.n282 0.9005
R1088 VDD.n286 VDD.n282 0.9005
R1089 VDD.n294 VDD.n286 0.9005
R1090 VDD.n294 VDD.n293 0.9005
R1091 VDD.n293 VDD.n289 0.9005
R1092 VDD.n290 VDD.n289 0.9005
R1093 VDD.n61 VDD.n13 0.874819
R1094 VDD.n35 VDD.n19 0.874819
R1095 VDD.n469 VDD.n465 0.7205
R1096 VDD.n470 VDD.n469 0.7205
R1097 VDD.n470 VDD.n464 0.7205
R1098 VDD.n474 VDD.n464 0.7205
R1099 VDD.n475 VDD.n474 0.7205
R1100 VDD.n475 VDD.n463 0.7205
R1101 VDD.n479 VDD.n463 0.7205
R1102 VDD.n480 VDD.n479 0.7205
R1103 VDD.n480 VDD.n462 0.7205
R1104 VDD.n483 VDD.n462 0.7205
R1105 VDD.n231 VDD.n230 0.6755
R1106 VDD.n232 VDD.n231 0.6755
R1107 VDD.n232 VDD.n227 0.6755
R1108 VDD.n236 VDD.n227 0.6755
R1109 VDD.n237 VDD.n236 0.6755
R1110 VDD.n238 VDD.n237 0.6755
R1111 VDD.n238 VDD.n225 0.6755
R1112 VDD.n242 VDD.n225 0.6755
R1113 VDD.n45 VDD.n17 0.666015
R1114 VDD.n52 VDD.n51 0.666015
R1115 VDD.n33 VDD.n20 0.664828
R1116 VDD.n244 VDD.n243 0.61925
R1117 VDD.n215 VDD.n214 0.6155
R1118 VDD.n49 VDD.n48 0.516313
R1119 VDD.n356 VDD.t132 0.4555
R1120 VDD.n356 VDD.t188 0.4555
R1121 VDD.n363 VDD.t19 0.4555
R1122 VDD.n363 VDD.t15 0.4555
R1123 VDD.n369 VDD.t60 0.4555
R1124 VDD.n369 VDD.t182 0.4555
R1125 VDD.n375 VDD.t171 0.4555
R1126 VDD.n375 VDD.t109 0.4555
R1127 VDD.n395 VDD.t73 0.4555
R1128 VDD.n395 VDD.t23 0.4555
R1129 VDD.n303 VDD.t214 0.4555
R1130 VDD.n303 VDD.t93 0.4555
R1131 VDD.n426 VDD.t75 0.4555
R1132 VDD.n426 VDD.t71 0.4555
R1133 VDD.n335 VDD.t193 0.4555
R1134 VDD.n335 VDD.t113 0.4555
R1135 VDD.n329 VDD.t1 0.4555
R1136 VDD.n329 VDD.t25 0.4555
R1137 VDD.n323 VDD.t11 0.4555
R1138 VDD.n323 VDD.t7 0.4555
R1139 VDD.n451 VDD.t212 0.4555
R1140 VDD.n451 VDD.t210 0.4555
R1141 VDD.n352 VDD.t186 0.4555
R1142 VDD.n352 VDD.t134 0.4555
R1143 VDD.n360 VDD.t36 0.4555
R1144 VDD.n360 VDD.t34 0.4555
R1145 VDD.n366 VDD.t107 0.4555
R1146 VDD.n366 VDD.t150 0.4555
R1147 VDD.n372 VDD.t46 0.4555
R1148 VDD.n372 VDD.t173 0.4555
R1149 VDD.n392 VDD.t205 0.4555
R1150 VDD.n392 VDD.t203 0.4555
R1151 VDD.n340 VDD.t21 0.4555
R1152 VDD.n340 VDD.t169 0.4555
R1153 VDD.n302 VDD.t129 0.4555
R1154 VDD.n302 VDD.t77 0.4555
R1155 VDD.n436 VDD.t44 0.4555
R1156 VDD.n436 VDD.t195 0.4555
R1157 VDD.n332 VDD.t48 0.4555
R1158 VDD.n332 VDD.t5 0.4555
R1159 VDD.n326 VDD.t89 0.4555
R1160 VDD.n326 VDD.t13 0.4555
R1161 VDD.n446 VDD.t83 0.4555
R1162 VDD.n446 VDD.t184 0.4555
R1163 VDD.n318 VDD.t127 0.4555
R1164 VDD.n318 VDD.t54 0.4555
R1165 VDD.n100 VDD.n98 0.4505
R1166 VDD.n121 VDD.n93 0.4505
R1167 VDD.n137 VDD.n136 0.4505
R1168 VDD.n139 VDD.n87 0.4505
R1169 VDD.n522 VDD.n267 0.4505
R1170 VDD.n9 VDD.n8 0.4055
R1171 VDD.n407 VDD.n355 0.3965
R1172 VDD.n460 VDD.n321 0.3965
R1173 VDD.n119 VDD.n117 0.39425
R1174 VDD.n78 VDD.t52 0.390639
R1175 VDD.n78 VDD.t3 0.390639
R1176 VDD.n159 VDD.n77 0.383
R1177 VDD.n70 VDD.t144 0.379667
R1178 VDD.n70 VDD.t40 0.379667
R1179 VDD.n72 VDD.t38 0.379667
R1180 VDD.n72 VDD.t177 0.379667
R1181 VDD.n47 VDD.n46 0.36725
R1182 VDD.n179 VDD.t167 0.3645
R1183 VDD.n179 VDD.t165 0.3645
R1184 VDD.n181 VDD.t125 0.3645
R1185 VDD.n181 VDD.t123 0.3645
R1186 VDD.n184 VDD.t121 0.3645
R1187 VDD.n184 VDD.t201 0.3645
R1188 VDD.n153 VDD.n80 0.36275
R1189 VDD.n407 VDD.n406 0.3605
R1190 VDD.n406 VDD.n405 0.3605
R1191 VDD.n405 VDD.n404 0.3605
R1192 VDD.n404 VDD.n403 0.3605
R1193 VDD.n403 VDD.n402 0.3605
R1194 VDD.n402 VDD.n401 0.3605
R1195 VDD.n401 VDD.n400 0.3605
R1196 VDD.n400 VDD.n399 0.3605
R1197 VDD.n399 VDD.n398 0.3605
R1198 VDD.n398 VDD.n339 0.3605
R1199 VDD.n339 VDD.n300 0.3605
R1200 VDD.n499 VDD.n301 0.3605
R1201 VDD.n439 VDD.n301 0.3605
R1202 VDD.n440 VDD.n439 0.3605
R1203 VDD.n441 VDD.n440 0.3605
R1204 VDD.n442 VDD.n441 0.3605
R1205 VDD.n443 VDD.n442 0.3605
R1206 VDD.n444 VDD.n443 0.3605
R1207 VDD.n445 VDD.n444 0.3605
R1208 VDD.n445 VDD.n320 0.3605
R1209 VDD.n460 VDD.n320 0.3605
R1210 VDD.n148 VDD.n147 0.34475
R1211 VDD.n412 VDD.n411 0.3205
R1212 VDD.n412 VDD.n343 0.3205
R1213 VDD.n418 VDD.n343 0.3205
R1214 VDD.n419 VDD.n418 0.3205
R1215 VDD.n419 VDD.n308 0.3205
R1216 VDD.n495 VDD.n308 0.3205
R1217 VDD.n495 VDD.n494 0.3205
R1218 VDD.n494 VDD.n309 0.3205
R1219 VDD.n488 VDD.n309 0.3205
R1220 VDD.n488 VDD.n487 0.3205
R1221 VDD.n284 VDD.n275 0.3155
R1222 VDD.n299 VDD.n296 0.3155
R1223 VDD.n378 VDD.n350 0.313132
R1224 VDD.n410 VDD.n351 0.313132
R1225 VDD.n413 VDD.n348 0.313132
R1226 VDD.n415 VDD.n346 0.313132
R1227 VDD.n417 VDD.n344 0.313132
R1228 VDD.n420 VDD.n341 0.313132
R1229 VDD.n305 VDD.n304 0.313132
R1230 VDD.n496 VDD.n306 0.313132
R1231 VDD.n493 VDD.n310 0.313132
R1232 VDD.n491 VDD.n312 0.313132
R1233 VDD.n489 VDD.n314 0.313132
R1234 VDD.n486 VDD.n317 0.313132
R1235 VDD.n409 VDD.n408 0.313132
R1236 VDD.n362 VDD.n349 0.313132
R1237 VDD.n414 VDD.n347 0.313132
R1238 VDD.n416 VDD.n345 0.313132
R1239 VDD.n394 VDD.n342 0.313132
R1240 VDD.n422 VDD.n421 0.313132
R1241 VDD.n498 VDD.n497 0.313132
R1242 VDD.n438 VDD.n307 0.313132
R1243 VDD.n492 VDD.n311 0.313132
R1244 VDD.n490 VDD.n313 0.313132
R1245 VDD.n447 VDD.n315 0.313132
R1246 VDD.n485 VDD.n461 0.313132
R1247 VDD.n455 VDD.n316 0.313132
R1248 VDD.n213 VDD.n212 0.299842
R1249 VDD.n48 VDD.n47 0.293563
R1250 VDD.n165 VDD.n75 0.293
R1251 VDD.n202 VDD.n174 0.293
R1252 VDD.n150 VDD.n83 0.28175
R1253 VDD.n160 VDD.n76 0.28175
R1254 VDD.n200 VDD.n176 0.28175
R1255 VDD.n101 VDD.n100 0.2705
R1256 VDD.n202 VDD.n201 0.2705
R1257 VDD.n198 VDD.n178 0.2705
R1258 VDD.n171 VDD.n170 0.24125
R1259 VDD.n500 VDD.n300 0.23225
R1260 VDD.n103 VDD.n97 0.2255
R1261 VDD.n108 VDD.n95 0.2255
R1262 VDD.n116 VDD.n114 0.2255
R1263 VDD.n120 VDD.n92 0.2255
R1264 VDD.n127 VDD.n125 0.2255
R1265 VDD.n131 VDD.n90 0.2255
R1266 VDD.n138 VDD.n86 0.2255
R1267 VDD.n142 VDD.n84 0.2255
R1268 VDD.n152 VDD.n82 0.2255
R1269 VDD.n164 VDD.n74 0.2255
R1270 VDD.n207 VDD.n206 0.2255
R1271 VDD.n151 VDD.n150 0.2255
R1272 VDD.n163 VDD.n161 0.2255
R1273 VDD.n200 VDD.n199 0.2255
R1274 VDD.n132 VDD.n88 0.221
R1275 VDD.n264 VDD.n253 0.21425
R1276 VDD.n102 VDD.n101 0.1805
R1277 VDD.n109 VDD.n97 0.1805
R1278 VDD.n113 VDD.n95 0.1805
R1279 VDD.n193 VDD.n183 0.1805
R1280 VDD.n189 VDD.n188 0.1805
R1281 VDD.n214 VDD.n213 0.1805
R1282 VDD.n501 VDD.n299 0.1805
R1283 VDD.n197 VDD.n196 0.17825
R1284 VDD.n189 VDD.n185 0.17825
R1285 VDD.n409 VDD.n350 0.1765
R1286 VDD.n82 VDD.n81 0.17375
R1287 VDD.n410 VDD.n409 0.1605
R1288 VDD.n410 VDD.n349 0.1605
R1289 VDD.n413 VDD.n349 0.1605
R1290 VDD.n414 VDD.n413 0.1605
R1291 VDD.n415 VDD.n414 0.1605
R1292 VDD.n416 VDD.n415 0.1605
R1293 VDD.n417 VDD.n416 0.1605
R1294 VDD.n417 VDD.n342 0.1605
R1295 VDD.n420 VDD.n342 0.1605
R1296 VDD.n421 VDD.n420 0.1605
R1297 VDD.n421 VDD.n305 0.1605
R1298 VDD.n497 VDD.n305 0.1605
R1299 VDD.n497 VDD.n496 0.1605
R1300 VDD.n496 VDD.n307 0.1605
R1301 VDD.n493 VDD.n307 0.1605
R1302 VDD.n493 VDD.n492 0.1605
R1303 VDD.n492 VDD.n491 0.1605
R1304 VDD.n491 VDD.n490 0.1605
R1305 VDD.n490 VDD.n489 0.1605
R1306 VDD.n489 VDD.n315 0.1605
R1307 VDD.n486 VDD.n315 0.1605
R1308 VDD.n486 VDD.n485 0.1605
R1309 VDD.n485 VDD.n484 0.1595
R1310 VDD.n121 VDD.n120 0.158
R1311 VDD.n125 VDD.n124 0.158
R1312 VDD.n126 VDD.n90 0.158
R1313 VDD.n133 VDD.n132 0.158
R1314 VDD.n138 VDD.n137 0.158
R1315 VDD.n143 VDD.n142 0.158
R1316 VDD.n157 VDD.n75 0.158
R1317 VDD.n165 VDD.n164 0.158
R1318 VDD.n169 VDD.n168 0.158
R1319 VDD.n221 VDD.n220 0.158
R1320 VDD.n171 VDD.n71 0.15575
R1321 VDD.n2 VDD.n0 0.150211
R1322 VDD.n456 VDD.n455 0.140237
R1323 VDD.n379 VDD.n378 0.140237
R1324 VDD.n357 VDD.n351 0.140237
R1325 VDD.n364 VDD.n348 0.140237
R1326 VDD.n370 VDD.n346 0.140237
R1327 VDD.n376 VDD.n344 0.140237
R1328 VDD.n396 VDD.n341 0.140237
R1329 VDD.n427 VDD.n306 0.140237
R1330 VDD.n336 VDD.n310 0.140237
R1331 VDD.n330 VDD.n312 0.140237
R1332 VDD.n324 VDD.n314 0.140237
R1333 VDD.n452 VDD.n317 0.140237
R1334 VDD.n408 VDD.n353 0.140237
R1335 VDD.n362 VDD.n361 0.140237
R1336 VDD.n367 VDD.n347 0.140237
R1337 VDD.n373 VDD.n345 0.140237
R1338 VDD.n394 VDD.n393 0.140237
R1339 VDD.n423 VDD.n422 0.140237
R1340 VDD.n438 VDD.n437 0.140237
R1341 VDD.n333 VDD.n311 0.140237
R1342 VDD.n327 VDD.n313 0.140237
R1343 VDD.n448 VDD.n447 0.140237
R1344 VDD.n461 VDD.n319 0.140237
R1345 VDD.n182 VDD.n180 0.13775
R1346 VDD.n500 VDD.n499 0.12875
R1347 VDD.n178 VDD.n175 0.12425
R1348 VDD.n209 VDD.n208 0.12425
R1349 VDD.n484 VDD.n483 0.12425
R1350 VDD.n115 VDD.n93 0.113
R1351 VDD.n105 VDD.n104 0.113
R1352 VDD.n107 VDD.n105 0.113
R1353 VDD.n107 VDD.n106 0.113
R1354 VDD.n117 VDD.n94 0.113
R1355 VDD.n119 VDD.n118 0.113
R1356 VDD.n118 VDD.n91 0.113
R1357 VDD.n128 VDD.n91 0.113
R1358 VDD.n129 VDD.n128 0.113
R1359 VDD.n130 VDD.n129 0.113
R1360 VDD.n130 VDD.n87 0.113
R1361 VDD.n140 VDD.n139 0.113
R1362 VDD.n141 VDD.n140 0.113
R1363 VDD.n141 VDD.n83 0.113
R1364 VDD.n151 VDD.n76 0.113
R1365 VDD.n161 VDD.n160 0.113
R1366 VDD.n163 VDD.n162 0.113
R1367 VDD.n162 VDD.n68 0.113
R1368 VDD.n208 VDD.n69 0.113
R1369 VDD.n176 VDD.n69 0.113
R1370 VDD.n199 VDD.n177 0.113
R1371 VDD.n186 VDD.n177 0.113
R1372 VDD.n191 VDD.n186 0.113
R1373 VDD.n191 VDD.n190 0.113
R1374 VDD.n147 VDD.n146 0.10625
R1375 VDD.n209 VDD.n68 0.10175
R1376 VDD.n8 VDD.n7 0.0952368
R1377 VDD.n174 VDD.n73 0.09275
R1378 VDD.n62 VDD.n12 0.0905
R1379 VDD.n251 VDD.n0 0.0902105
R1380 VDD.n183 VDD.n182 0.08825
R1381 VDD.n136 VDD.n88 0.0725
R1382 VDD.n116 VDD.n115 0.068
R1383 VDD.n124 VDD.n92 0.068
R1384 VDD.n127 VDD.n126 0.068
R1385 VDD.n133 VDD.n131 0.068
R1386 VDD.n143 VDD.n86 0.068
R1387 VDD.n146 VDD.n84 0.068
R1388 VDD.n168 VDD.n74 0.068
R1389 VDD.n206 VDD.n205 0.068
R1390 VDD.n94 VDD.n67 0.068
R1391 VDD.n205 VDD.n73 0.06575
R1392 VDD.n158 VDD.n157 0.06125
R1393 VDD.n201 VDD.n175 0.05675
R1394 VDD.n170 VDD.n169 0.05225
R1395 VDD.n192 VDD.n185 0.04775
R1396 VDD.n429 VDD.n425 0.0462143
R1397 VDD.n457 VDD.n321 0.0455609
R1398 VDD.n406 VDD.n358 0.0455609
R1399 VDD.n404 VDD.n365 0.0455609
R1400 VDD.n402 VDD.n371 0.0455609
R1401 VDD.n400 VDD.n377 0.0455609
R1402 VDD.n398 VDD.n397 0.0455609
R1403 VDD.n428 VDD.n301 0.0455609
R1404 VDD.n440 VDD.n337 0.0455609
R1405 VDD.n442 VDD.n331 0.0455609
R1406 VDD.n444 VDD.n325 0.0455609
R1407 VDD.n453 VDD.n320 0.0455609
R1408 VDD.n407 VDD.n354 0.0455609
R1409 VDD.n405 VDD.n359 0.0455609
R1410 VDD.n403 VDD.n368 0.0455609
R1411 VDD.n401 VDD.n374 0.0455609
R1412 VDD.n399 VDD.n391 0.0455609
R1413 VDD.n424 VDD.n339 0.0455609
R1414 VDD.n439 VDD.n435 0.0455609
R1415 VDD.n441 VDD.n334 0.0455609
R1416 VDD.n443 VDD.n328 0.0455609
R1417 VDD.n449 VDD.n445 0.0455609
R1418 VDD.n460 VDD.n459 0.0455609
R1419 VDD.n380 VDD.n355 0.0455609
R1420 VDD.n49 VDD.n12 0.0455
R1421 VDD.n103 VDD.n102 0.0455
R1422 VDD.n109 VDD.n108 0.0455
R1423 VDD.n114 VDD.n113 0.0455
R1424 VDD.n149 VDD.n148 0.0455
R1425 VDD.n153 VDD.n152 0.0455
R1426 VDD.n196 VDD.n180 0.0455
R1427 VDD.n193 VDD.n192 0.0455
R1428 VDD.n106 VDD.n67 0.0455
R1429 VDD.n149 VDD.n80 0.04325
R1430 VDD.n188 VDD.n187 0.03875
R1431 VDD.n63 VDD.n10 0.023
R1432 VDD.n66 VDD.n10 0.023
R1433 VDD.n223 VDD.n4 0.023
R1434 VDD.n221 VDD.n4 0.023
R1435 VDD.n220 VDD.n216 0.023
R1436 VDD.n218 VDD.n216 0.023
R1437 VDD.n250 VDD.n1 0.023
R1438 VDD.n242 VDD.n241 0.0212323
R1439 VDD.n484 VDD.n316 0.0175
R1440 VDD.n382 VDD.n381 0.0172619
R1441 VDD.n383 VDD.n382 0.0157381
R1442 VDD.n384 VDD.n383 0.0157381
R1443 VDD.n385 VDD.n384 0.0157381
R1444 VDD.n386 VDD.n385 0.0157381
R1445 VDD.n387 VDD.n386 0.0157381
R1446 VDD.n388 VDD.n387 0.0157381
R1447 VDD.n389 VDD.n388 0.0157381
R1448 VDD.n390 VDD.n389 0.0157381
R1449 VDD.n390 VDD.n338 0.0157381
R1450 VDD.n425 VDD.n338 0.0157381
R1451 VDD.n434 VDD.n429 0.0157381
R1452 VDD.n434 VDD.n433 0.0157381
R1453 VDD.n433 VDD.n432 0.0157381
R1454 VDD.n432 VDD.n431 0.0157381
R1455 VDD.n431 VDD.n430 0.0157381
R1456 VDD.n430 VDD.n322 0.0157381
R1457 VDD.n450 VDD.n322 0.0157381
R1458 VDD.n454 VDD.n450 0.0157381
R1459 VDD.n458 VDD.n454 0.0157381
R1460 VDD VDD.n252 0.0135
R1461 VDD.n2 VDD.n1 0.01175
R1462 VDD.n251 VDD.n250 0.01175
R1463 VDD.n65 VDD.n64 0.0105
R1464 VDD.n64 VDD.n11 0.0105
R1465 VDD.n219 VDD.n217 0.0105
R1466 VDD.n217 VDD.n215 0.0105
R1467 VDD.n222 VDD.n5 0.0105
R1468 VDD.n5 VDD.n3 0.0105
R1469 VDD.n249 VDD.n248 0.0105
R1470 VDD.n248 VDD.n247 0.0105
R1471 VDD.n81 VDD.n77 0.00725
R1472 VDD.n159 VDD.n158 0.00725
R1473 VDD.n16 VDD.n15 0.00568217
R1474 VDD.n207 VDD.n71 0.00275
R1475 VDD.n198 VDD.n197 0.00275
R1476 DOUBLER_K.n0 DOUBLER_K.t2 18.1653
R1477 DOUBLER_K.n0 DOUBLER_K.t3 13.7268
R1478 DOUBLER_K DOUBLER_K.n0 4.5005
R1479 VSS.n617 VSS.t197 1.99209e+07
R1480 VSS.n617 VSS.n20 433875
R1481 VSS.n523 VSS.n20 195213
R1482 VSS.n618 VSS.n617 111058
R1483 VSS.n616 VSS.n21 79092.8
R1484 VSS.n471 VSS.n470 69464.5
R1485 VSS.n490 VSS.t161 41312.5
R1486 VSS.n617 VSS.n616 39936.7
R1487 VSS.t8 VSS.n64 33917.3
R1488 VSS.n471 VSS.n469 19761.5
R1489 VSS.n470 VSS.n20 19680.6
R1490 VSS.n535 VSS.t197 18534.9
R1491 VSS.n519 VSS.n71 11955.6
R1492 VSS.n523 VSS.t197 10390.2
R1493 VSS.n491 VSS.n88 9941.42
R1494 VSS.n492 VSS.n491 5648.06
R1495 VSS.n224 VSS.n88 4042.28
R1496 VSS.n385 VSS.t76 4036.95
R1497 VSS.t2 VSS.n223 3653.23
R1498 VSS.n516 VSS.n73 3300.07
R1499 VSS.n518 VSS.n72 3133.7
R1500 VSS.n525 VSS.n524 2492.95
R1501 VSS.n225 VSS.t2 2466.37
R1502 VSS.n517 VSS.t195 2275.91
R1503 VSS.n223 VSS.n141 2253.37
R1504 VSS.n520 VSS.n519 1950.83
R1505 VSS.n492 VSS.t71 1798.54
R1506 VSS.t70 VSS.n71 1679.62
R1507 VSS.n64 VSS.n21 1583.17
R1508 VSS.n225 VSS.n224 1569.95
R1509 VSS.n519 VSS.t221 1521.28
R1510 VSS.n536 VSS.n21 1515.12
R1511 VSS.t14 VSS.n518 1455.97
R1512 VSS.t59 VSS.t205 1402.31
R1513 VSS.t42 VSS.t156 1402.31
R1514 VSS.t213 VSS.t40 1083.33
R1515 VSS.t219 VSS.t154 1083.33
R1516 VSS.t207 VSS.t90 1083.33
R1517 VSS.t146 VSS.t57 1083.33
R1518 VSS.n367 VSS.n71 1034.09
R1519 VSS.t8 VSS.t16 971.971
R1520 VSS.n140 VSS.n126 902.779
R1521 VSS.n253 VSS.n126 902.779
R1522 VSS.n254 VSS.n253 902.779
R1523 VSS.n259 VSS.n258 902.779
R1524 VSS.n261 VSS.n259 902.779
R1525 VSS.n269 VSS.n118 902.779
R1526 VSS.n270 VSS.n269 902.779
R1527 VSS.n271 VSS.n270 902.779
R1528 VSS.n275 VSS.n116 902.779
R1529 VSS.n276 VSS.n275 902.779
R1530 VSS.n308 VSS.n307 902.779
R1531 VSS.n307 VSS.n306 902.779
R1532 VSS.n306 VSS.n277 902.779
R1533 VSS.n302 VSS.n301 902.779
R1534 VSS.n301 VSS.n300 902.779
R1535 VSS.n300 VSS.n279 902.779
R1536 VSS.n296 VSS.n295 902.779
R1537 VSS.n295 VSS.n294 902.779
R1538 VSS.n294 VSS.n286 902.779
R1539 VSS.n290 VSS.n289 902.779
R1540 VSS.n289 VSS.n288 902.779
R1541 VSS.n258 VSS.t106 889.236
R1542 VSS.t67 VSS.n116 864.41
R1543 VSS.n290 VSS.t53 855.383
R1544 VSS.n381 VSS.t39 744.856
R1545 VSS.t195 VSS.t70 728.292
R1546 VSS.n288 VSS.t202 726.736
R1547 VSS.n522 VSS.n520 721.268
R1548 VSS.t105 VSS.n276 717.708
R1549 VSS.n261 VSS.t49 704.168
R1550 VSS.n523 VSS.t65 680.234
R1551 VSS.n296 VSS.t74 631.944
R1552 VSS.t221 VSS.t14 614.658
R1553 VSS.t37 VSS.n118 595.833
R1554 VSS.n223 VSS.n222 499.736
R1555 VSS.n518 VSS.n517 495.567
R1556 VSS.t51 VSS.n277 494.272
R1557 VSS.t80 VSS.n254 460.418
R1558 VSS.n224 VSS.t44 457.053
R1559 VSS.t101 VSS.t103 455.904
R1560 VSS.n255 VSS.t80 442.361
R1561 VSS.n302 VSS.t51 408.507
R1562 VSS.t88 VSS.n73 394.214
R1563 VSS.n381 VSS.t144 394.214
R1564 VSS.t217 VSS.n73 394.214
R1565 VSS.n381 VSS.t211 394.214
R1566 VSS.n380 VSS.t190 370.908
R1567 VSS.n491 VSS.n366 338.543
R1568 VSS.t103 VSS.n140 331.772
R1569 VSS.n517 VSS.n516 318.627
R1570 VSS.t161 VSS.t27 315.534
R1571 VSS.n381 VSS.n73 304.002
R1572 VSS.t25 VSS.t29 299.632
R1573 VSS.n451 VSS.n450 295.12
R1574 VSS.n441 VSS.n401 295.12
R1575 VSS.n441 VSS.n440 295.12
R1576 VSS.n440 VSS.n402 295.12
R1577 VSS.n430 VSS.n402 295.12
R1578 VSS.n429 VSS.n410 295.12
R1579 VSS.n420 VSS.n410 295.12
R1580 VSS.n615 VSS.n22 295.12
R1581 VSS.n32 VSS.n22 295.12
R1582 VSS.n599 VSS.n33 295.12
R1583 VSS.n588 VSS.n41 295.12
R1584 VSS.n54 VSS.n41 295.12
R1585 VSS.n401 VSS.t215 286.267
R1586 VSS.t209 VSS.n599 275.937
R1587 VSS.t74 VSS.n279 270.834
R1588 VSS.n381 VSS.n380 264.5
R1589 VSS.t40 VSS.t88 261.807
R1590 VSS.t205 VSS.t213 261.807
R1591 VSS.t154 VSS.t59 261.807
R1592 VSS.t144 VSS.t219 261.807
R1593 VSS.t90 VSS.t217 261.807
R1594 VSS.t156 VSS.t207 261.807
R1595 VSS.t57 VSS.t42 261.807
R1596 VSS.t211 VSS.t146 261.807
R1597 VSS.t93 VSS.n429 259.705
R1598 VSS.t16 VSS.n536 252.856
R1599 VSS.t35 VSS.t37 252.779
R1600 VSS.n565 VSS.n564 250.851
R1601 VSS.n462 VSS.n460 246.425
R1602 VSS.t9 VSS.t68 242.369
R1603 VSS.t99 VSS.n33 219.864
R1604 VSS.n472 VSS.n464 203.779
R1605 VSS.n564 VSS.t5 201.865
R1606 VSS.n465 VSS.n464 200.862
R1607 VSS.t44 VSS.t17 199.755
R1608 VSS.t21 VSS.t64 199.755
R1609 VSS.t29 VSS.t61 199.755
R1610 VSS.t49 VSS.n260 198.612
R1611 VSS.n472 VSS.n383 191.917
R1612 VSS.n468 VSS.n383 191.917
R1613 VSS.t22 VSS.t92 191.827
R1614 VSS.t193 VSS.t166 191.827
R1615 VSS.t68 VSS.n502 190.433
R1616 VSS.n505 VSS.t25 190.433
R1617 VSS.t164 VSS.n534 190.433
R1618 VSS.t27 VSS.t71 189.321
R1619 VSS.n308 VSS.t105 185.07
R1620 VSS.t76 VSS.t109 184.45
R1621 VSS.t64 VSS.n504 180.446
R1622 VSS.n366 VSS.t202 176.042
R1623 VSS.n565 VSS.t200 175.596
R1624 VSS.t73 VSS.t6 161.476
R1625 VSS.t6 VSS.t8 153.856
R1626 VSS.n420 VSS.t55 151.987
R1627 VSS.n340 VSS.n339 146.572
R1628 VSS.n340 VSS.n99 146.572
R1629 VSS.n345 VSS.n99 146.572
R1630 VSS.n346 VSS.n345 146.572
R1631 VSS.n346 VSS.n96 146.572
R1632 VSS.n352 VSS.n96 146.572
R1633 VSS.n353 VSS.n352 146.572
R1634 VSS.n354 VSS.n353 146.572
R1635 VSS.n360 VSS.n93 146.572
R1636 VSS.t45 VSS.t73 145.583
R1637 VSS.n354 VSS.t7 138.756
R1638 VSS.n338 VSS.n337 124.588
R1639 VSS.n535 VSS.t164 124.18
R1640 VSS.t5 VSS.t24 121.743
R1641 VSS.t0 VSS.t19 118.049
R1642 VSS.t97 VSS.t11 118.049
R1643 VSS.t11 VSS.t162 118.049
R1644 VSS.t150 VSS.t152 118.049
R1645 VSS.t148 VSS.t150 118.049
R1646 VSS.t86 VSS.t84 118.049
R1647 VSS.t200 VSS.t82 118.049
R1648 VSS.t84 VSS.n572 116.573
R1649 VSS.n141 VSS.t101 115.105
R1650 VSS.t24 VSS.t45 113.796
R1651 VSS.n616 VSS.t33 112.883
R1652 VSS.n490 VSS.t158 99.4723
R1653 VSS.n392 VSS.t22 98.8654
R1654 VSS.n600 VSS.t0 98.8654
R1655 VSS.t166 VSS.n392 92.963
R1656 VSS.n245 VSS.n132 92.1033
R1657 VSS.n241 VSS.n132 92.1033
R1658 VSS.n241 VSS.n240 92.1033
R1659 VSS.n240 VSS.n137 92.1033
R1660 VSS.n235 VSS.n137 92.1033
R1661 VSS.n235 VSS.n234 92.1033
R1662 VSS.n233 VSS.n226 92.1033
R1663 VSS.n315 VSS.n106 92.1033
R1664 VSS.n320 VSS.n106 92.1033
R1665 VSS.n321 VSS.n320 92.1033
R1666 VSS.n322 VSS.n321 92.1033
R1667 VSS.n322 VSS.n103 92.1033
R1668 VSS.n329 VSS.n103 92.1033
R1669 VSS.n314 VSS.n110 78.2879
R1670 VSS.t19 VSS.n32 78.2071
R1671 VSS.n361 VSS.n360 75.7296
R1672 VSS.n589 VSS.t99 75.2559
R1673 VSS.n491 VSS.n89 73.2292
R1674 VSS.t13 VSS.t48 72.3012
R1675 VSS.n361 VSS.n89 70.8439
R1676 VSS.n226 VSS.n225 65.3935
R1677 VSS.t95 VSS.n370 65.2991
R1678 VSS.n573 VSS.t86 60.4999
R1679 VSS.n222 VSS.n142 60.0122
R1680 VSS.n337 VSS.t192 58.3852
R1681 VSS.n573 VSS.t148 57.5487
R1682 VSS.n518 VSS.t4 55.4883
R1683 VSS.n260 VSS.t35 54.1672
R1684 VSS.n220 VSS.n219 51.5781
R1685 VSS.n215 VSS.n149 51.5781
R1686 VSS.n153 VSS.n150 51.5781
R1687 VSS.n210 VSS.n154 51.5781
R1688 VSS.n207 VSS.n206 51.5781
R1689 VSS.n203 VSS.n164 51.5781
R1690 VSS.n168 VSS.n165 51.5781
R1691 VSS.n199 VSS.n169 51.5781
R1692 VSS.n196 VSS.n195 51.5781
R1693 VSS.n192 VSS.n191 51.5781
R1694 VSS.n470 VSS.t95 51.5274
R1695 VSS.n536 VSS.n535 50.244
R1696 VSS.t108 VSS.t192 49.8351
R1697 VSS.n330 VSS.t3 49.3977
R1698 VSS.t53 VSS.n286 47.3963
R1699 VSS.n491 VSS.t31 47.2842
R1700 VSS.n520 VSS.t4 47.2839
R1701 VSS.n246 VSS.n245 44.5168
R1702 VSS.n589 VSS.t97 42.7928
R1703 VSS.n196 VSS.n169 40.5257
R1704 VSS.n192 VSS.n131 40.5257
R1705 VSS.n271 VSS.t67 38.3686
R1706 VSS.n331 VSS.n330 36.5772
R1707 VSS.n184 VSS.t23 35.9712
R1708 VSS.n430 VSS.t93 35.4148
R1709 VSS.n463 VSS.n462 33.2014
R1710 VSS.t109 VSS.n384 32.4636
R1711 VSS.n130 VSS.t199 29.6712
R1712 VSS.n248 VSS.t46 28.9355
R1713 VSS.n195 VSS.t188 28.8594
R1714 VSS.n225 VSS.n110 26.7103
R1715 VSS.t31 VSS.n490 26.2832
R1716 VSS.n144 VSS.n142 25.1753
R1717 VSS.n219 VSS.n145 25.1753
R1718 VSS.n215 VSS.n214 25.1753
R1719 VSS.n211 VSS.n153 25.1753
R1720 VSS.n157 VSS.n154 25.1753
R1721 VSS.n206 VSS.n158 25.1753
R1722 VSS.n203 VSS.n202 25.1753
R1723 VSS.n200 VSS.n168 25.1753
R1724 VSS.t92 VSS.n371 25.1405
R1725 VSS.t33 VSS.n615 25.0856
R1726 VSS.n371 VSS.t194 24.7701
R1727 VSS.n183 VSS.t189 24.341
R1728 VSS.n462 VSS.n461 24.2319
R1729 VSS.n380 VSS.n379 24.0907
R1730 VSS.n333 VSS.n332 23.9328
R1731 VSS.n330 VSS.n102 23.6065
R1732 VSS.n486 VSS.t157 23.4006
R1733 VSS.n369 VSS.t60 23.4006
R1734 VSS.n374 VSS.t212 23.3466
R1735 VSS.n382 VSS.n381 23.162
R1736 VSS.n504 VSS.t9 22.6393
R1737 VSS.n378 VSS.t191 22.4555
R1738 VSS.n461 VSS.t110 22.3205
R1739 VSS.n339 VSS.n338 21.9864
R1740 VSS.n332 VSS.n331 19.9859
R1741 VSS.n228 VSS.n111 19.8545
R1742 VSS.n509 VSS.n72 19.5545
R1743 VSS.n600 VSS.t209 19.1832
R1744 VSS.n521 VSS.n68 19.1555
R1745 VSS.n481 VSS.t206 18.5991
R1746 VSS.n484 VSS.t89 18.5991
R1747 VSS.n375 VSS.t43 18.5991
R1748 VSS.n175 VSS.n143 18.5855
R1749 VSS.n374 VSS.t58 18.56
R1750 VSS.n483 VSS.t214 18.56
R1751 VSS.n482 VSS.t41 18.506
R1752 VSS.n369 VSS.t220 18.506
R1753 VSS.n377 VSS.t147 18.428
R1754 VSS.n283 VSS.t54 18.3449
R1755 VSS.n331 VSS.n88 18.3382
R1756 VSS.n282 VSS.t75 18.3359
R1757 VSS.n362 VSS.n361 18.3148
R1758 VSS.n379 VSS.t96 18.0491
R1759 VSS.n280 VSS.t52 17.4278
R1760 VSS.n247 VSS.n246 16.6401
R1761 VSS.n338 VSS.n92 16.5284
R1762 VSS.n314 VSS.n313 16.4549
R1763 VSS.n291 VSS.n91 16.2455
R1764 VSS.n285 VSS.n284 16.2455
R1765 VSS.n299 VSS.n281 16.2455
R1766 VSS.n304 VSS.n113 16.2455
R1767 VSS.n310 VSS.n309 16.2455
R1768 VSS.n273 VSS.n112 16.2455
R1769 VSS.n268 VSS.n267 16.2455
R1770 VSS.n263 VSS.n262 16.2455
R1771 VSS.n251 VSS.n250 16.2455
R1772 VSS.t162 VSS.n588 16.2321
R1773 VSS.n503 VSS.n75 16.213
R1774 VSS.n500 VSS.t69 16.1466
R1775 VSS.n74 VSS.t159 16.1466
R1776 VSS.n87 VSS.t28 16.1466
R1777 VSS.n507 VSS.t26 16.122
R1778 VSS.n67 VSS.t165 16.0975
R1779 VSS.n186 VSS.n185 15.8855
R1780 VSS.t158 VSS.n489 15.8456
R1781 VSS.t48 VSS.n233 15.8115
R1782 VSS.n489 VSS.n488 15.556
R1783 VSS.n463 VSS.n384 15.4943
R1784 VSS.n489 VSS.n367 15.4683
R1785 VSS.n220 VSS.n144 15.351
R1786 VSS.n149 VSS.n145 15.351
R1787 VSS.n214 VSS.n150 15.351
R1788 VSS.n211 VSS.n210 15.351
R1789 VSS.n207 VSS.n157 15.351
R1790 VSS.n164 VSS.n158 15.351
R1791 VSS.n202 VSS.n165 15.351
R1792 VSS.n618 VSS.t141 15.2946
R1793 VSS.n529 VSS.n528 14.9947
R1794 VSS.n512 VSS.n511 14.903
R1795 VSS.n497 VSS.n496 14.903
R1796 VSS.n476 VSS.n370 14.9005
R1797 VSS.n499 VSS.n498 14.8985
R1798 VSS.n510 VSS.n508 14.8985
R1799 VSS.n530 VSS.n529 14.8985
R1800 VSS.n332 VSS.t108 14.8012
R1801 VSS.n182 VSS.n129 14.1759
R1802 VSS.t76 VSS.n64 14.1514
R1803 VSS.n477 VSS.t145 14.0991
R1804 VSS.n488 VSS.t218 14.0991
R1805 VSS.n480 VSS.t155 13.8305
R1806 VSS.n368 VSS.t208 13.8305
R1807 VSS.n485 VSS.t91 13.8305
R1808 VSS.n315 VSS.n314 13.8159
R1809 VSS.n475 VSS.n474 13.7986
R1810 VSS.n524 VSS.t78 13.7235
R1811 VSS.n363 VSS.n362 13.6805
R1812 VSS.n312 VSS.n311 13.6805
R1813 VSS.n249 VSS.n248 13.6805
R1814 VSS.n619 VSS.n15 13.633
R1815 VSS.n255 VSS.t106 13.5422
R1816 VSS.n458 VSS.n457 13.5005
R1817 VSS.n456 VSS.n388 13.5005
R1818 VSS.n455 VSS.n454 13.5005
R1819 VSS.n453 VSS.n389 13.5005
R1820 VSS.n393 VSS.n391 13.5005
R1821 VSS.n395 VSS.n394 13.5005
R1822 VSS.n448 VSS.n447 13.5005
R1823 VSS.n446 VSS.n397 13.5005
R1824 VSS.n445 VSS.n444 13.5005
R1825 VSS.n443 VSS.n398 13.5005
R1826 VSS.n405 VSS.n400 13.5005
R1827 VSS.n406 VSS.n403 13.5005
R1828 VSS.n438 VSS.n437 13.5005
R1829 VSS.n436 VSS.n404 13.5005
R1830 VSS.n435 VSS.n434 13.5005
R1831 VSS.n433 VSS.n407 13.5005
R1832 VSS.n413 VSS.n409 13.5005
R1833 VSS.n414 VSS.n411 13.5005
R1834 VSS.n427 VSS.n426 13.5005
R1835 VSS.n425 VSS.n412 13.5005
R1836 VSS.n424 VSS.n423 13.5005
R1837 VSS.n422 VSS.n415 13.5005
R1838 VSS.n419 VSS.n418 13.5005
R1839 VSS.n25 VSS.n23 13.5005
R1840 VSS.n613 VSS.n612 13.5005
R1841 VSS.n611 VSS.n610 13.5005
R1842 VSS.n608 VSS.n26 13.5005
R1843 VSS.n607 VSS.n606 13.5005
R1844 VSS.n605 VSS.n604 13.5005
R1845 VSS.n603 VSS.n28 13.5005
R1846 VSS.n36 VSS.n31 13.5005
R1847 VSS.n37 VSS.n34 13.5005
R1848 VSS.n597 VSS.n596 13.5005
R1849 VSS.n595 VSS.n35 13.5005
R1850 VSS.n594 VSS.n593 13.5005
R1851 VSS.n591 VSS.n38 13.5005
R1852 VSS.n46 VSS.n40 13.5005
R1853 VSS.n47 VSS.n44 13.5005
R1854 VSS.n586 VSS.n585 13.5005
R1855 VSS.n584 VSS.n583 13.5005
R1856 VSS.n581 VSS.n48 13.5005
R1857 VSS.n580 VSS.n579 13.5005
R1858 VSS.n578 VSS.n577 13.5005
R1859 VSS.n576 VSS.n50 13.5005
R1860 VSS.n60 VSS.n53 13.5005
R1861 VSS.n61 VSS.n57 13.5005
R1862 VSS.n570 VSS.n569 13.5005
R1863 VSS.n568 VSS.n567 13.5005
R1864 VSS.n63 VSS.n62 13.5005
R1865 VSS.n539 VSS.n537 13.5005
R1866 VSS.n561 VSS.n560 13.5005
R1867 VSS.n559 VSS.n558 13.5005
R1868 VSS.n549 VSS.n540 13.5005
R1869 VSS.n551 VSS.n550 13.5005
R1870 VSS.n553 VSS.n552 13.5005
R1871 VSS.n548 VSS.n3 13.5005
R1872 VSS.n635 VSS.n634 13.5005
R1873 VSS.n632 VSS.n4 13.5005
R1874 VSS.n13 VSS.n7 13.5005
R1875 VSS.n14 VSS.n10 13.5005
R1876 VSS.n626 VSS.n625 13.5005
R1877 VSS.n624 VSS.n12 13.5005
R1878 VSS.n623 VSS.n622 13.5005
R1879 VSS.n621 VSS.n15 13.5005
R1880 VSS.n72 VSS.t204 13.3665
R1881 VSS.n521 VSS.t66 13.3208
R1882 VSS.n563 VSS.t111 13.2935
R1883 VSS.n78 VSS.t47 12.0546
R1884 VSS.n76 VSS.t160 12.0546
R1885 VSS.n65 VSS.t30 12.0546
R1886 VSS.n513 VSS.t15 12.0546
R1887 VSS.n494 VSS.t143 12.0546
R1888 VSS.n191 VSS.t188 11.6669
R1889 VSS.t3 VSS.n329 11.6669
R1890 VSS.t113 VSS.t111 11.4354
R1891 VSS.t115 VSS.t117 11.4354
R1892 VSS.t119 VSS.t121 11.4354
R1893 VSS.t121 VSS.t123 11.4354
R1894 VSS.t125 VSS.t127 11.4354
R1895 VSS.t129 VSS.t131 11.4354
R1896 VSS.t131 VSS.t133 11.4354
R1897 VSS.t137 VSS.t135 11.4354
R1898 VSS.t141 VSS.t139 11.4354
R1899 VSS.n266 VSS.n265 11.3855
R1900 VSS.n129 VSS.n128 11.3045
R1901 VSS.n141 VSS.n127 11.3005
R1902 VSS.n78 VSS.t18 11.2798
R1903 VSS.n76 VSS.t63 11.2798
R1904 VSS.n65 VSS.t62 11.2798
R1905 VSS.n513 VSS.t196 11.2798
R1906 VSS.n494 VSS.t72 11.2798
R1907 VSS.n503 VSS.t10 11.0891
R1908 VSS.n186 VSS.n131 11.0755
R1909 VSS.n70 VSS.t79 10.9509
R1910 VSS.n527 VSS.t198 10.9058
R1911 VSS.n364 VSS.t203 10.8914
R1912 VSS.n151 VSS.n144 10.7605
R1913 VSS.n201 VSS.n200 10.7605
R1914 VSS.n524 VSS.n523 10.4072
R1915 VSS.n358 VSS.n89 10.4065
R1916 VSS.n337 VSS.n336 10.4005
R1917 VSS.n339 VSS.n101 10.4005
R1918 VSS.n341 VSS.n340 10.4005
R1919 VSS.n343 VSS.n99 10.4005
R1920 VSS.n345 VSS.n344 10.4005
R1921 VSS.n347 VSS.n346 10.4005
R1922 VSS.n348 VSS.n96 10.4005
R1923 VSS.n352 VSS.n351 10.4005
R1924 VSS.n353 VSS.n95 10.4005
R1925 VSS.n355 VSS.n354 10.4005
R1926 VSS.n357 VSS.n93 10.4005
R1927 VSS.n360 VSS.n359 10.4005
R1928 VSS.n140 VSS.n127 10.4005
R1929 VSS.n251 VSS.n126 10.4005
R1930 VSS.n253 VSS.n252 10.4005
R1931 VSS.n254 VSS.n123 10.4005
R1932 VSS.n256 VSS.n255 10.4005
R1933 VSS.n258 VSS.n257 10.4005
R1934 VSS.n259 VSS.n121 10.4005
R1935 VSS.n262 VSS.n261 10.4005
R1936 VSS.n260 VSS.n122 10.4005
R1937 VSS.n119 VSS.n118 10.4005
R1938 VSS.n269 VSS.n268 10.4005
R1939 VSS.n270 VSS.n117 10.4005
R1940 VSS.n272 VSS.n271 10.4005
R1941 VSS.n273 VSS.n116 10.4005
R1942 VSS.n275 VSS.n274 10.4005
R1943 VSS.n276 VSS.n114 10.4005
R1944 VSS.n309 VSS.n308 10.4005
R1945 VSS.n307 VSS.n115 10.4005
R1946 VSS.n306 VSS.n305 10.4005
R1947 VSS.n304 VSS.n277 10.4005
R1948 VSS.n303 VSS.n302 10.4005
R1949 VSS.n301 VSS.n278 10.4005
R1950 VSS.n300 VSS.n299 10.4005
R1951 VSS.n298 VSS.n279 10.4005
R1952 VSS.n297 VSS.n296 10.4005
R1953 VSS.n295 VSS.n285 10.4005
R1954 VSS.n294 VSS.n293 10.4005
R1955 VSS.n292 VSS.n286 10.4005
R1956 VSS.n291 VSS.n290 10.4005
R1957 VSS.n289 VSS.n287 10.4005
R1958 VSS.n288 VSS.n90 10.4005
R1959 VSS.n366 VSS.n365 10.4005
R1960 VSS.n146 VSS.n142 10.4005
R1961 VSS.n219 VSS.n218 10.4005
R1962 VSS.n216 VSS.n215 10.4005
R1963 VSS.n153 VSS.n148 10.4005
R1964 VSS.n161 VSS.n154 10.4005
R1965 VSS.n206 VSS.n205 10.4005
R1966 VSS.n204 VSS.n203 10.4005
R1967 VSS.n188 VSS.n168 10.4005
R1968 VSS.n189 VSS.n169 10.4005
R1969 VSS.n195 VSS.n194 10.4005
R1970 VSS.n193 VSS.n192 10.4005
R1971 VSS.n245 VSS.n244 10.4005
R1972 VSS.n243 VSS.n132 10.4005
R1973 VSS.n242 VSS.n241 10.4005
R1974 VSS.n240 VSS.n239 10.4005
R1975 VSS.n238 VSS.n137 10.4005
R1976 VSS.n236 VSS.n235 10.4005
R1977 VSS.n234 VSS.n139 10.4005
R1978 VSS.n233 VSS.n232 10.4005
R1979 VSS.n230 VSS.n226 10.4005
R1980 VSS.n229 VSS.n110 10.4005
R1981 VSS.n316 VSS.n315 10.4005
R1982 VSS.n317 VSS.n106 10.4005
R1983 VSS.n320 VSS.n319 10.4005
R1984 VSS.n321 VSS.n105 10.4005
R1985 VSS.n323 VSS.n322 10.4005
R1986 VSS.n325 VSS.n103 10.4005
R1987 VSS.n329 VSS.n328 10.4005
R1988 VSS.n221 VSS.n220 10.4005
R1989 VSS.n149 VSS.n143 10.4005
R1990 VSS.n155 VSS.n150 10.4005
R1991 VSS.n210 VSS.n209 10.4005
R1992 VSS.n208 VSS.n207 10.4005
R1993 VSS.n164 VSS.n156 10.4005
R1994 VSS.n170 VSS.n165 10.4005
R1995 VSS.n199 VSS.n198 10.4005
R1996 VSS.n197 VSS.n196 10.4005
R1997 VSS.n191 VSS.n186 10.4005
R1998 VSS.n151 VSS.n145 10.4005
R1999 VSS.n214 VSS.n213 10.4005
R2000 VSS.n212 VSS.n211 10.4005
R2001 VSS.n166 VSS.n157 10.4005
R2002 VSS.n167 VSS.n158 10.4005
R2003 VSS.n202 VSS.n201 10.4005
R2004 VSS.n619 VSS.n618 10.4005
R2005 VSS.n19 VSS.n18 10.4005
R2006 VSS.n629 VSS.n628 10.4005
R2007 VSS.n631 VSS.n630 10.4005
R2008 VSS.n543 VSS.n5 10.4005
R2009 VSS.n555 VSS.n554 10.4005
R2010 VSS.n557 VSS.n556 10.4005
R2011 VSS.n563 VSS.n562 10.4005
R2012 VSS.n566 VSS.n565 10.4005
R2013 VSS.n572 VSS.n571 10.4005
R2014 VSS.n574 VSS.n573 10.4005
R2015 VSS.n54 VSS.n51 10.4005
R2016 VSS.n582 VSS.n41 10.4005
R2017 VSS.n588 VSS.n587 10.4005
R2018 VSS.n590 VSS.n589 10.4005
R2019 VSS.n39 VSS.n33 10.4005
R2020 VSS.n599 VSS.n598 10.4005
R2021 VSS.n601 VSS.n600 10.4005
R2022 VSS.n32 VSS.n29 10.4005
R2023 VSS.n609 VSS.n22 10.4005
R2024 VSS.n615 VSS.n614 10.4005
R2025 VSS.n421 VSS.n420 10.4005
R2026 VSS.n416 VSS.n410 10.4005
R2027 VSS.n429 VSS.n428 10.4005
R2028 VSS.n431 VSS.n430 10.4005
R2029 VSS.n408 VSS.n402 10.4005
R2030 VSS.n440 VSS.n439 10.4005
R2031 VSS.n442 VSS.n441 10.4005
R2032 VSS.n401 VSS.n399 10.4005
R2033 VSS.n450 VSS.n449 10.4005
R2034 VSS.n452 VSS.n451 10.4005
R2035 VSS.n392 VSS.n390 10.4005
R2036 VSS.n460 VSS.n459 10.4005
R2037 VSS.n386 VSS.n384 10.4005
R2038 VSS.n451 VSS.t193 10.3297
R2039 VSS.n637 VSS.n636 10.012
R2040 VSS.t32 VSS.n199 9.8248
R2041 VSS.t117 VSS.n555 9.57719
R2042 VSS.n630 VSS.t127 9.57719
R2043 VSS.n19 VSS.t137 9.57719
R2044 VSS.n174 VSS.n156 9.5765
R2045 VSS.n365 VSS.n364 9.446
R2046 VSS.n256 VSS.n125 9.4415
R2047 VSS.n502 VSS.t17 9.32236
R2048 VSS.n505 VSS.t21 9.32236
R2049 VSS.n534 VSS.t61 9.32236
R2050 VSS.n476 VSS.n475 9.2525
R2051 VSS.n488 VSS.n487 9.248
R2052 VSS.n385 VSS.t77 9.10571
R2053 VSS.n183 VSS.n182 9.06238
R2054 VSS.n478 VSS.n2 9.053
R2055 VSS.n364 VSS.n363 9.05
R2056 VSS.n478 VSS.n477 9.00997
R2057 VSS.n174 VSS.n173 9.0005
R2058 VSS VSS.n1 9.0005
R2059 VSS.n450 VSS.t215 8.85407
R2060 VSS.t7 VSS.n93 7.8177
R2061 VSS.n556 VSS.t115 7.57609
R2062 VSS.n543 VSS.t125 7.57609
R2063 VSS.n629 VSS.t135 7.57609
R2064 VSS.n246 VSS.n131 7.06171
R2065 VSS.n367 VSS.n73 6.917
R2066 VSS.n457 VSS.n387 6.8666
R2067 VSS.n128 VSS.t102 6.84275
R2068 VSS.n125 VSS.n120 6.8045
R2069 VSS.n124 VSS.t81 6.7685
R2070 VSS.n312 VSS.n92 6.37925
R2071 VSS.n124 VSS.t107 6.341
R2072 VSS.n175 VSS.n174 6.3095
R2073 VSS.n128 VSS.t104 6.26675
R2074 VSS.n265 VSS.n264 6.24686
R2075 VSS.n265 VSS.t38 6.02636
R2076 VSS.n200 VSS.t32 5.52667
R2077 VSS.n362 VSS.n92 5.27675
R2078 VSS.n466 VSS.n465 5.2005
R2079 VSS.n468 VSS.n467 5.2005
R2080 VSS.n616 VSS.t55 5.16509
R2081 VSS.n482 VSS.n481 4.802
R2082 VSS.n376 VSS.n375 4.79373
R2083 VSS.n484 VSS.n483 4.748
R2084 VSS.n487 VSS.n368 4.73
R2085 VSS.n480 VSS.n479 4.73
R2086 VSS.n486 VSS.n485 4.676
R2087 VSS.n469 VSS.n465 4.63138
R2088 VSS.n498 VSS.n86 4.532
R2089 VSS.n532 VSS.n531 4.5005
R2090 VSS.n125 VSS.n124 4.5005
R2091 VSS.n85 VSS.n80 4.5005
R2092 VSS.n85 VSS.n84 4.5005
R2093 VSS.n82 VSS.n81 4.5005
R2094 VSS.n83 VSS.n80 4.5005
R2095 VSS.n84 VSS.n83 4.5005
R2096 VSS.n180 VSS.n178 4.5005
R2097 VSS.n178 VSS.n176 4.5005
R2098 VSS.n181 VSS.n177 4.5005
R2099 VSS.n180 VSS.n179 4.5005
R2100 VSS.n179 VSS.n176 4.5005
R2101 VSS.n526 VSS.n69 4.5005
R2102 VSS.n460 VSS.t92 4.42729
R2103 VSS.n564 VSS.n563 4.28857
R2104 VSS.n396 VSS.t216 4.03076
R2105 VSS.n234 VSS.t13 3.99162
R2106 VSS.n248 VSS.n247 3.94925
R2107 VSS.n556 VSS.t113 3.85976
R2108 VSS.t123 VSS.n543 3.85976
R2109 VSS.t133 VSS.n629 3.85976
R2110 VSS.n24 VSS.t34 3.76313
R2111 VSS.n417 VSS.t56 3.76313
R2112 VSS.n130 VSS.n111 3.713
R2113 VSS.n27 VSS.t20 3.09644
R2114 VSS.n432 VSS.t94 3.04534
R2115 VSS.t65 VSS.n522 3.02376
R2116 VSS.n475 VSS.n371 2.84725
R2117 VSS.n247 VSS.n130 2.82425
R2118 VSS.n185 VSS.n175 2.7005
R2119 VSS.n263 VSS.n120 2.7005
R2120 VSS.n267 VSS.n112 2.7005
R2121 VSS.n310 VSS.n113 2.7005
R2122 VSS.n49 VSS.t153 2.64609
R2123 VSS.n45 VSS.t163 2.62155
R2124 VSS.n592 VSS.t100 2.62155
R2125 VSS.n522 VSS.n521 2.6005
R2126 VSS.n473 VSS.n373 2.48024
R2127 VSS.n466 VSS.n373 2.44471
R2128 VSS.n620 VSS.t142 2.39335
R2129 VSS.n538 VSS.t112 2.39335
R2130 VSS.n467 VSS.n372 2.33576
R2131 VSS.n532 VSS.n67 2.2987
R2132 VSS.n311 VSS.n112 2.2955
R2133 VSS.n284 VSS.n283 2.28425
R2134 VSS.n528 VSS.n527 2.26612
R2135 VSS.n180 VSS.n86 2.16831
R2136 VSS.n86 VSS.n85 2.11351
R2137 VSS.n602 VSS.n30 2.01721
R2138 VSS.n281 VSS.n280 1.8905
R2139 VSS.n555 VSS.t119 1.85866
R2140 VSS.n630 VSS.t129 1.85866
R2141 VSS.t139 VSS.n19 1.85866
R2142 VSS.n152 VSS.n0 0.930804
R2143 VSS.n250 VSS.n249 1.8005
R2144 VSS.n43 VSS.n42 1.78155
R2145 VSS.n59 VSS.n58 1.76497
R2146 VSS.n56 VSS.n55 1.76497
R2147 VSS.n575 VSS.n52 1.76497
R2148 VSS.n173 VSS.t185 1.712
R2149 VSS.n222 VSS.n221 1.69011
R2150 VSS.n382 VSS.n370 1.67482
R2151 VSS.n282 VSS.n281 1.598
R2152 VSS.n17 VSS.n16 1.58695
R2153 VSS.n627 VSS.n11 1.58695
R2154 VSS.n9 VSS.n8 1.58695
R2155 VSS.n633 VSS.n6 1.58695
R2156 VSS.n547 VSS.n546 1.58695
R2157 VSS.n545 VSS.n544 1.58695
R2158 VSS.n542 VSS.n541 1.58695
R2159 VSS.n499 VSS.n79 1.57622
R2160 VSS.n514 VSS.n512 1.56045
R2161 VSS.n496 VSS.n495 1.56045
R2162 VSS.n70 VSS.n69 1.5602
R2163 VSS.n474 VSS.n372 1.55892
R2164 VSS.n507 VSS.n506 1.55407
R2165 VSS.t152 VSS.n54 1.4761
R2166 VSS.n572 VSS.t82 1.4761
R2167 VSS.n266 VSS.n263 1.4405
R2168 VSS.n485 VSS.n484 1.40765
R2169 VSS.n504 VSS.n503 1.31114
R2170 VSS.n146 VSS.t184 1.26595
R2171 VSS.n267 VSS.n266 1.2605
R2172 VSS.n531 VSS.n66 1.21383
R2173 VSS.n508 VSS.n77 1.17783
R2174 VSS.n250 VSS.n129 1.1705
R2175 VSS.n501 VSS.n500 1.13798
R2176 VSS.n515 VSS.n74 1.13798
R2177 VSS.n493 VSS.n87 1.13798
R2178 VSS.n284 VSS.n282 1.103
R2179 VSS.n358 VSS.t167 1.05964
R2180 VSS.n0 VSS.t186 0.306617
R2181 VSS.n172 VSS.n171 0.967665
R2182 VSS.n481 VSS.n480 0.951118
R2183 VSS.n251 VSS.n127 0.9005
R2184 VSS.n252 VSS.n251 0.9005
R2185 VSS.n252 VSS.n123 0.9005
R2186 VSS.n256 VSS.n123 0.9005
R2187 VSS.n257 VSS.n256 0.9005
R2188 VSS.n257 VSS.n121 0.9005
R2189 VSS.n262 VSS.n121 0.9005
R2190 VSS.n262 VSS.n122 0.9005
R2191 VSS.n122 VSS.n119 0.9005
R2192 VSS.n268 VSS.n119 0.9005
R2193 VSS.n268 VSS.n117 0.9005
R2194 VSS.n272 VSS.n117 0.9005
R2195 VSS.n273 VSS.n272 0.9005
R2196 VSS.n274 VSS.n273 0.9005
R2197 VSS.n274 VSS.n114 0.9005
R2198 VSS.n309 VSS.n114 0.9005
R2199 VSS.n309 VSS.n115 0.9005
R2200 VSS.n305 VSS.n115 0.9005
R2201 VSS.n305 VSS.n304 0.9005
R2202 VSS.n304 VSS.n303 0.9005
R2203 VSS.n303 VSS.n278 0.9005
R2204 VSS.n299 VSS.n278 0.9005
R2205 VSS.n299 VSS.n298 0.9005
R2206 VSS.n298 VSS.n297 0.9005
R2207 VSS.n297 VSS.n285 0.9005
R2208 VSS.n293 VSS.n285 0.9005
R2209 VSS.n293 VSS.n292 0.9005
R2210 VSS.n292 VSS.n291 0.9005
R2211 VSS.n291 VSS.n287 0.9005
R2212 VSS.n287 VSS.n90 0.9005
R2213 VSS.n365 VSS.n90 0.9005
R2214 VSS.n249 VSS.n120 0.9005
R2215 VSS.n378 VSS.n377 0.86225
R2216 VSS.n280 VSS.n113 0.8105
R2217 VSS.n510 VSS.n509 0.79475
R2218 VSS.n474 VSS.n473 0.772605
R2219 VSS.n487 VSS.n486 0.761
R2220 VSS.n483 VSS.n482 0.761
R2221 VSS.n479 VSS.n369 0.761
R2222 VSS.n376 VSS.n374 0.74075
R2223 VSS.n30 VSS.t1 0.701999
R2224 VSS.n30 VSS.t210 0.701999
R2225 VSS.n477 VSS.n476 0.688955
R2226 VSS.n221 VSS.n143 0.6755
R2227 VSS.n155 VSS.n143 0.6755
R2228 VSS.n209 VSS.n155 0.6755
R2229 VSS.n209 VSS.n208 0.6755
R2230 VSS.n208 VSS.n156 0.6755
R2231 VSS.n170 VSS.n156 0.6755
R2232 VSS.n198 VSS.n170 0.6755
R2233 VSS.n198 VSS.n197 0.6755
R2234 VSS.n197 VSS.n186 0.6755
R2235 VSS.n497 VSS.n75 0.6755
R2236 VSS.n182 VSS.n181 0.652935
R2237 VSS.n493 VSS.n492 0.6505
R2238 VSS.n516 VSS.n515 0.6505
R2239 VSS.n502 VSS.n501 0.6505
R2240 VSS.n506 VSS.n505 0.6505
R2241 VSS.n534 VSS.n533 0.6505
R2242 VSS.n375 VSS.n368 0.638102
R2243 VSS.n58 VSS.t83 0.573227
R2244 VSS.n58 VSS.t201 0.573227
R2245 VSS.n55 VSS.t87 0.573227
R2246 VSS.n55 VSS.t85 0.573227
R2247 VSS.n52 VSS.t151 0.573227
R2248 VSS.n52 VSS.t149 0.573227
R2249 VSS.n184 VSS.n183 0.563
R2250 VSS.n511 VSS.n75 0.563
R2251 VSS.n461 VSS.n371 0.556468
R2252 VSS.n637 VSS.n2 0.547167
R2253 VSS.n42 VSS.t98 0.5465
R2254 VSS.n42 VSS.t12 0.5465
R2255 VSS.n217 VSS.n147 0.535665
R2256 VSS.n160 VSS.n159 0.535665
R2257 VSS.n163 VSS.n162 0.535665
R2258 VSS.n190 VSS.n187 0.535665
R2259 VSS.n134 VSS.n133 0.535665
R2260 VSS.n136 VSS.n135 0.535665
R2261 VSS.n237 VSS.n138 0.535665
R2262 VSS.n231 VSS.n227 0.535665
R2263 VSS.n109 VSS.n108 0.535665
R2264 VSS.n318 VSS.n107 0.535665
R2265 VSS.n324 VSS.n104 0.535665
R2266 VSS.n327 VSS.n326 0.535665
R2267 VSS.n335 VSS.n334 0.535665
R2268 VSS.n342 VSS.n100 0.535665
R2269 VSS.n98 VSS.n97 0.535665
R2270 VSS.n350 VSS.n349 0.535665
R2271 VSS.n356 VSS.n94 0.535665
R2272 VSS.n16 VSS.t138 0.52466
R2273 VSS.n16 VSS.t140 0.52466
R2274 VSS.n11 VSS.t134 0.52466
R2275 VSS.n11 VSS.t136 0.52466
R2276 VSS.n8 VSS.t130 0.52466
R2277 VSS.n8 VSS.t132 0.52466
R2278 VSS.n6 VSS.t126 0.52466
R2279 VSS.n6 VSS.t128 0.52466
R2280 VSS.n546 VSS.t122 0.52466
R2281 VSS.n546 VSS.t124 0.52466
R2282 VSS.n544 VSS.t118 0.52466
R2283 VSS.n544 VSS.t120 0.52466
R2284 VSS.n541 VSS.t114 0.52466
R2285 VSS.n541 VSS.t116 0.52466
R2286 VSS.n147 VSS.t183 0.4793
R2287 VSS.n147 VSS.t184 0.4793
R2288 VSS.n159 VSS.t182 0.4793
R2289 VSS.n159 VSS.t183 0.4793
R2290 VSS.n162 VSS.t181 0.4793
R2291 VSS.n162 VSS.t182 0.4793
R2292 VSS.n187 VSS.t180 0.4793
R2293 VSS.n187 VSS.t181 0.4793
R2294 VSS.n133 VSS.t179 0.4793
R2295 VSS.n133 VSS.t180 0.4793
R2296 VSS.n135 VSS.t178 0.4793
R2297 VSS.n135 VSS.t179 0.4793
R2298 VSS.n138 VSS.t177 0.4793
R2299 VSS.n138 VSS.t178 0.4793
R2300 VSS.n227 VSS.t176 0.4793
R2301 VSS.n227 VSS.t177 0.4793
R2302 VSS.n108 VSS.t175 0.4793
R2303 VSS.n108 VSS.t176 0.4793
R2304 VSS.n107 VSS.t174 0.4793
R2305 VSS.n107 VSS.t175 0.4793
R2306 VSS.n104 VSS.t173 0.4793
R2307 VSS.n104 VSS.t174 0.4793
R2308 VSS.n326 VSS.t172 0.4793
R2309 VSS.n326 VSS.t173 0.4793
R2310 VSS.n334 VSS.t171 0.4793
R2311 VSS.n334 VSS.t172 0.4793
R2312 VSS.n100 VSS.t170 0.4793
R2313 VSS.n100 VSS.t171 0.4793
R2314 VSS.n97 VSS.t169 0.4793
R2315 VSS.n97 VSS.t170 0.4793
R2316 VSS.n349 VSS.t168 0.4793
R2317 VSS.n349 VSS.t169 0.4793
R2318 VSS.n94 VSS.t167 0.4793
R2319 VSS.n94 VSS.t168 0.4793
R2320 VSS.n363 VSS.n91 0.4505
R2321 VSS.n313 VSS.n111 0.43925
R2322 VSS.n283 VSS.n91 0.41675
R2323 VSS.n311 VSS.n310 0.4055
R2324 VSS.n313 VSS.n312 0.37175
R2325 VSS.n213 VSS.n151 0.3605
R2326 VSS.n213 VSS.n212 0.3605
R2327 VSS.n167 VSS.n166 0.3605
R2328 VSS.n201 VSS.n167 0.3605
R2329 VSS.n80 VSS.n2 0.355
R2330 VSS.n172 VSS.n152 0.3011
R2331 VSS.n509 VSS.n68 0.29525
R2332 VSS.n473 VSS.n472 0.274184
R2333 VSS.n472 VSS.n471 0.274184
R2334 VSS.n0 VSS.t187 0.141508
R2335 VSS.n171 VSS.t185 0.2324
R2336 VSS.n171 VSS.t186 0.2324
R2337 VSS.n479 VSS.n478 0.228757
R2338 VSS.n185 VSS.n184 0.2255
R2339 VSS.n379 VSS.n378 0.219364
R2340 VSS.n383 VSS.n372 0.217167
R2341 VSS.n383 VSS.n382 0.217167
R2342 VSS.n464 VSS.n373 0.2085
R2343 VSS.n464 VSS.n463 0.2085
R2344 VSS VSS.n637 0.207827
R2345 VSS.n264 VSS.t50 0.20525
R2346 VSS.n264 VSS.t36 0.20525
R2347 VSS.n386 VSS.n385 0.2005
R2348 VSS.n212 VSS.n152 0.1805
R2349 VSS.n166 VSS.n152 0.1805
R2350 VSS.n218 VSS.n146 0.154786
R2351 VSS.n216 VSS.n148 0.154786
R2352 VSS.n205 VSS.n161 0.154786
R2353 VSS.n205 VSS.n204 0.154786
R2354 VSS.n189 VSS.n188 0.154786
R2355 VSS.n194 VSS.n193 0.154786
R2356 VSS.n244 VSS.n243 0.154786
R2357 VSS.n243 VSS.n242 0.154786
R2358 VSS.n239 VSS.n238 0.154786
R2359 VSS.n236 VSS.n139 0.154786
R2360 VSS.n232 VSS.n139 0.154786
R2361 VSS.n230 VSS.n229 0.154786
R2362 VSS.n317 VSS.n316 0.154786
R2363 VSS.n319 VSS.n105 0.154786
R2364 VSS.n323 VSS.n105 0.154786
R2365 VSS.n328 VSS.n325 0.154786
R2366 VSS.n333 VSS.n102 0.154786
R2367 VSS.n336 VSS.n333 0.154786
R2368 VSS.n341 VSS.n101 0.154786
R2369 VSS.n344 VSS.n343 0.154786
R2370 VSS.n348 VSS.n347 0.154786
R2371 VSS.n351 VSS.n348 0.154786
R2372 VSS.n355 VSS.n95 0.154786
R2373 VSS.n359 VSS.n357 0.154786
R2374 VSS.n193 VSS.n134 0.150671
R2375 VSS.n173 VSS.n172 0.1499
R2376 VSS.n359 VSS.n358 0.149729
R2377 VSS.n529 VSS.n68 0.149
R2378 VSS.n335 VSS.n101 0.1445
R2379 VSS.n318 VSS.n317 0.140386
R2380 VSS.n231 VSS.n230 0.134214
R2381 VSS.n459 VSS.n387 0.13061
R2382 VSS.n344 VSS.n98 0.1301
R2383 VSS.n160 VSS.n148 0.125986
R2384 VSS.n188 VSS.n163 0.123929
R2385 VSS.n469 VSS.n468 0.120251
R2386 VSS.n350 VSS.n95 0.119814
R2387 VSS.n238 VSS.n237 0.1157
R2388 VSS.n77 VSS.n76 0.113439
R2389 VSS.n66 VSS.n65 0.113439
R2390 VSS.n498 VSS.n497 0.113
R2391 VSS.n511 VSS.n510 0.113
R2392 VSS.n457 VSS.n456 0.113
R2393 VSS.n456 VSS.n455 0.113
R2394 VSS.n455 VSS.n389 0.113
R2395 VSS.n393 VSS.n389 0.113
R2396 VSS.n394 VSS.n393 0.113
R2397 VSS.n447 VSS.n446 0.113
R2398 VSS.n446 VSS.n445 0.113
R2399 VSS.n445 VSS.n398 0.113
R2400 VSS.n405 VSS.n398 0.113
R2401 VSS.n406 VSS.n405 0.113
R2402 VSS.n437 VSS.n406 0.113
R2403 VSS.n437 VSS.n436 0.113
R2404 VSS.n436 VSS.n435 0.113
R2405 VSS.n435 VSS.n407 0.113
R2406 VSS.n413 VSS.n407 0.113
R2407 VSS.n414 VSS.n413 0.113
R2408 VSS.n426 VSS.n414 0.113
R2409 VSS.n426 VSS.n425 0.113
R2410 VSS.n425 VSS.n424 0.113
R2411 VSS.n424 VSS.n415 0.113
R2412 VSS.n418 VSS.n415 0.113
R2413 VSS.n418 VSS.n25 0.113
R2414 VSS.n612 VSS.n25 0.113
R2415 VSS.n612 VSS.n611 0.113
R2416 VSS.n611 VSS.n26 0.113
R2417 VSS.n606 VSS.n26 0.113
R2418 VSS.n606 VSS.n605 0.113
R2419 VSS.n605 VSS.n28 0.113
R2420 VSS.n36 VSS.n28 0.113
R2421 VSS.n37 VSS.n36 0.113
R2422 VSS.n596 VSS.n37 0.113
R2423 VSS.n596 VSS.n595 0.113
R2424 VSS.n595 VSS.n594 0.113
R2425 VSS.n594 VSS.n38 0.113
R2426 VSS.n46 VSS.n38 0.113
R2427 VSS.n47 VSS.n46 0.113
R2428 VSS.n585 VSS.n47 0.113
R2429 VSS.n585 VSS.n584 0.113
R2430 VSS.n584 VSS.n48 0.113
R2431 VSS.n579 VSS.n48 0.113
R2432 VSS.n579 VSS.n578 0.113
R2433 VSS.n578 VSS.n50 0.113
R2434 VSS.n60 VSS.n50 0.113
R2435 VSS.n61 VSS.n60 0.113
R2436 VSS.n569 VSS.n61 0.113
R2437 VSS.n569 VSS.n568 0.113
R2438 VSS.n568 VSS.n62 0.113
R2439 VSS.n539 VSS.n62 0.113
R2440 VSS.n560 VSS.n539 0.113
R2441 VSS.n560 VSS.n559 0.113
R2442 VSS.n559 VSS.n540 0.113
R2443 VSS.n551 VSS.n540 0.113
R2444 VSS.n552 VSS.n551 0.113
R2445 VSS.n552 VSS.n3 0.113
R2446 VSS.n635 VSS.n4 0.113
R2447 VSS.n13 VSS.n4 0.113
R2448 VSS.n14 VSS.n13 0.113
R2449 VSS.n625 VSS.n14 0.113
R2450 VSS.n625 VSS.n624 0.113
R2451 VSS.n624 VSS.n623 0.113
R2452 VSS.n623 VSS.n15 0.113
R2453 VSS.n325 VSS.n324 0.109529
R2454 VSS.n328 VSS.n327 0.105414
R2455 VSS.n512 VSS.n74 0.103094
R2456 VSS.n496 VSS.n87 0.103094
R2457 VSS.n458 VSS.n388 0.1005
R2458 VSS.n454 VSS.n453 0.1005
R2459 VSS.n395 VSS.n391 0.1005
R2460 VSS.n448 VSS.n397 0.1005
R2461 VSS.n444 VSS.n443 0.1005
R2462 VSS.n403 VSS.n400 0.1005
R2463 VSS.n438 VSS.n404 0.1005
R2464 VSS.n434 VSS.n433 0.1005
R2465 VSS.n411 VSS.n409 0.1005
R2466 VSS.n427 VSS.n412 0.1005
R2467 VSS.n423 VSS.n422 0.1005
R2468 VSS.n608 VSS.n607 0.1005
R2469 VSS.n604 VSS.n603 0.1005
R2470 VSS.n34 VSS.n31 0.1005
R2471 VSS.n597 VSS.n35 0.1005
R2472 VSS.n581 VSS.n580 0.1005
R2473 VSS.n577 VSS.n576 0.1005
R2474 VSS.n537 VSS.n63 0.1005
R2475 VSS.n550 VSS.n549 0.1005
R2476 VSS.n553 VSS.n548 0.1005
R2477 VSS.n626 VSS.n12 0.1005
R2478 VSS.n622 VSS.n621 0.1005
R2479 VSS.n239 VSS.n136 0.0992429
R2480 VSS.n514 VSS.n513 0.0983236
R2481 VSS.n495 VSS.n494 0.0983236
R2482 VSS.n79 VSS.n78 0.0983224
R2483 VSS.n356 VSS.n355 0.0951286
R2484 VSS.n190 VSS.n189 0.0910143
R2485 VSS.n217 VSS.n216 0.0889571
R2486 VSS.n500 VSS.n499 0.0868944
R2487 VSS.n343 VSS.n342 0.0848429
R2488 VSS.n508 VSS.n507 0.0840305
R2489 VSS.n610 VSS.n24 0.0835
R2490 VSS.n558 VSS.n538 0.0815
R2491 VSS.n390 VSS.n388 0.0805
R2492 VSS.n453 VSS.n452 0.0805
R2493 VSS.n399 VSS.n397 0.0805
R2494 VSS.n443 VSS.n442 0.0805
R2495 VSS.n439 VSS.n403 0.0805
R2496 VSS.n408 VSS.n404 0.0805
R2497 VSS.n428 VSS.n411 0.0805
R2498 VSS.n416 VSS.n412 0.0805
R2499 VSS.n422 VSS.n421 0.0805
R2500 VSS.n614 VSS.n23 0.0805
R2501 VSS.n610 VSS.n609 0.0805
R2502 VSS.n598 VSS.n34 0.0805
R2503 VSS.n39 VSS.n35 0.0805
R2504 VSS.n591 VSS.n590 0.0805
R2505 VSS.n587 VSS.n44 0.0805
R2506 VSS.n583 VSS.n582 0.0805
R2507 VSS.n571 VSS.n57 0.0805
R2508 VSS.n567 VSS.n566 0.0805
R2509 VSS.n562 VSS.n537 0.0805
R2510 VSS.n558 VSS.n557 0.0805
R2511 VSS.n632 VSS.n631 0.0805
R2512 VSS.n628 VSS.n10 0.0805
R2513 VSS.n607 VSS.n27 0.0795
R2514 VSS.n575 VSS.n574 0.0795
R2515 VSS.n567 VSS.n59 0.0795
R2516 VSS.n583 VSS.n45 0.0775
R2517 VSS.n593 VSS.n592 0.0755
R2518 VSS.n316 VSS.n109 0.0745571
R2519 VSS.n634 VSS.n633 0.0735
R2520 VSS.n417 VSS.n23 0.0715
R2521 VSS.n387 VSS.n386 0.071023
R2522 VSS.n342 VSS.n341 0.0704429
R2523 VSS.n447 VSS.n1 0.068
R2524 VSS.n636 VSS.n635 0.068
R2525 VSS.n547 VSS.n5 0.0675
R2526 VSS.n10 VSS.n9 0.0675
R2527 VSS.n218 VSS.n217 0.0663286
R2528 VSS.n194 VSS.n190 0.0642714
R2529 VSS.n530 VSS.n67 0.0632998
R2530 VSS.n56 VSS.n53 0.0615
R2531 VSS.n357 VSS.n356 0.0601571
R2532 VSS.n467 VSS.n466 0.0597105
R2533 VSS.n377 VSS.n376 0.0574388
R2534 VSS.n501 VSS.n79 0.0569545
R2535 VSS.n515 VSS.n514 0.0569533
R2536 VSS.n495 VSS.n493 0.0569533
R2537 VSS.n528 VSS.n69 0.0565154
R2538 VSS.n242 VSS.n136 0.0560429
R2539 VSS.n603 VSS.n602 0.0535
R2540 VSS.n51 VSS.n49 0.0535
R2541 VSS.n550 VSS.n545 0.0535
R2542 VSS.n17 VSS.n12 0.0535
R2543 VSS.n620 VSS.n619 0.0535
R2544 VSS.n44 VSS.n43 0.0515
R2545 VSS.n433 VSS.n432 0.0505
R2546 VSS.n228 VSS.n109 0.0498714
R2547 VSS.n327 VSS.n102 0.0498714
R2548 VSS.n43 VSS.n40 0.0495
R2549 VSS.n449 VSS.n396 0.0485
R2550 VSS.n533 VSS.n532 0.0482
R2551 VSS.n526 VSS.n525 0.0482
R2552 VSS.n324 VSS.n323 0.0457571
R2553 VSS.n394 VSS.n1 0.0455
R2554 VSS.n636 VSS.n3 0.0455
R2555 VSS.n506 VSS.n77 0.0423191
R2556 VSS.n533 VSS.n66 0.0423191
R2557 VSS.n525 VSS.n70 0.0419054
R2558 VSS.n237 VSS.n236 0.0395857
R2559 VSS.n57 VSS.n56 0.0395
R2560 VSS.n527 VSS.n526 0.0365
R2561 VSS.n351 VSS.n350 0.0354714
R2562 VSS.n9 VSS.n7 0.0335
R2563 VSS.n396 VSS.n395 0.0325
R2564 VSS.n204 VSS.n163 0.0313571
R2565 VSS.n229 VSS.n228 0.0313571
R2566 VSS.n432 VSS.n431 0.0305
R2567 VSS.n419 VSS.n417 0.0295
R2568 VSS.n161 VSS.n160 0.0293
R2569 VSS.n602 VSS.n601 0.0275
R2570 VSS.n580 VSS.n49 0.0275
R2571 VSS.n554 VSS.n545 0.0275
R2572 VSS.n633 VSS.n632 0.0275
R2573 VSS.n18 VSS.n17 0.0275
R2574 VSS.n621 VSS.n620 0.0275
R2575 VSS.n592 VSS.n591 0.0255
R2576 VSS.n347 VSS.n98 0.0251857
R2577 VSS.n586 VSS.n45 0.0235
R2578 VSS.n178 VSS.n177 0.023
R2579 VSS.n179 VSS.n177 0.023
R2580 VSS.n85 VSS.n81 0.023
R2581 VSS.n83 VSS.n81 0.023
R2582 VSS.n570 VSS.n59 0.0215
R2583 VSS.n232 VSS.n231 0.0210714
R2584 VSS.n459 VSS.n458 0.0205
R2585 VSS.n454 VSS.n390 0.0205
R2586 VSS.n452 VSS.n391 0.0205
R2587 VSS.n449 VSS.n448 0.0205
R2588 VSS.n444 VSS.n399 0.0205
R2589 VSS.n442 VSS.n400 0.0205
R2590 VSS.n439 VSS.n438 0.0205
R2591 VSS.n434 VSS.n408 0.0205
R2592 VSS.n431 VSS.n409 0.0205
R2593 VSS.n428 VSS.n427 0.0205
R2594 VSS.n423 VSS.n416 0.0205
R2595 VSS.n421 VSS.n419 0.0205
R2596 VSS.n614 VSS.n613 0.0205
R2597 VSS.n609 VSS.n608 0.0205
R2598 VSS.n604 VSS.n29 0.0205
R2599 VSS.n601 VSS.n31 0.0205
R2600 VSS.n598 VSS.n597 0.0205
R2601 VSS.n593 VSS.n39 0.0205
R2602 VSS.n590 VSS.n40 0.0205
R2603 VSS.n587 VSS.n586 0.0205
R2604 VSS.n582 VSS.n581 0.0205
R2605 VSS.n577 VSS.n51 0.0205
R2606 VSS.n574 VSS.n53 0.0205
R2607 VSS.n571 VSS.n570 0.0205
R2608 VSS.n566 VSS.n63 0.0205
R2609 VSS.n562 VSS.n561 0.0205
R2610 VSS.n554 VSS.n553 0.0205
R2611 VSS.n634 VSS.n5 0.0205
R2612 VSS.n631 VSS.n7 0.0205
R2613 VSS.n622 VSS.n18 0.0205
R2614 VSS.n561 VSS.n538 0.0195
R2615 VSS.n613 VSS.n24 0.0175
R2616 VSS.n319 VSS.n318 0.0149
R2617 VSS.n557 VSS.n542 0.0135
R2618 VSS.n548 VSS.n547 0.0135
R2619 VSS.n628 VSS.n627 0.0135
R2620 VSS.n336 VSS.n335 0.0107857
R2621 VSS.n84 VSS.n82 0.0105
R2622 VSS.n82 VSS.n80 0.0105
R2623 VSS.n181 VSS.n176 0.0105
R2624 VSS.n181 VSS.n180 0.0105
R2625 VSS.n531 VSS.n530 0.0095
R2626 VSS.n549 VSS.n542 0.0075
R2627 VSS.n627 VSS.n626 0.0075
R2628 VSS.n244 VSS.n134 0.00461429
R2629 VSS.n29 VSS.n27 0.0015
R2630 VSS.n576 VSS.n575 0.0015
R2631 a_9124_n19574.t1 a_9124_n19574.n0 22.2059
R2632 a_9124_n19574.n0 a_9124_n19574.t0 18.7816
R2633 a_9124_n19574.n0 a_9124_n19574.t2 15.4044
R2634 a_13714_n17054.n0 a_13714_n17054.t3 0.2735
R2635 a_13714_n17054.t5 a_13714_n17054.n0 0.2735
R2636 a_13714_n17054.n0 a_13714_n17054.n2 10.61
R2637 a_13714_n17054.n2 a_13714_n17054.n5 5.11025
R2638 a_13714_n17054.n5 a_13714_n17054.n4 17.7215
R2639 a_13714_n17054.n4 a_13714_n17054.t6 21.2717
R2640 a_13714_n17054.n4 a_13714_n17054.t7 21.0558
R2641 a_13714_n17054.n5 a_13714_n17054.n3 29.0118
R2642 a_13714_n17054.n3 a_13714_n17054.t0 0.303833
R2643 a_13714_n17054.n3 a_13714_n17054.t1 0.303833
R2644 a_13714_n17054.n2 a_13714_n17054.n1 9.0005
R2645 a_13714_n17054.n1 a_13714_n17054.t4 20.9387
R2646 a_13714_n17054.n1 a_13714_n17054.t2 21.3888
R2647 a_9934_n17054.t0 a_9934_n17054.n0 6.302
R2648 a_9934_n17054.n0 a_9934_n17054.n3 9.5495
R2649 a_9934_n17054.n3 a_9934_n17054.n2 13.9145
R2650 a_9934_n17054.n2 a_9934_n17054.t3 6.7565
R2651 a_9934_n17054.n2 a_9934_n17054.t1 6.302
R2652 a_9934_n17054.n3 a_9934_n17054.n1 19.6714
R2653 a_9934_n17054.n1 a_9934_n17054.t2 0.228
R2654 a_9934_n17054.n1 a_9934_n17054.t4 0.228
R2655 a_9934_n17054.n0 a_9934_n17054.t5 6.7565
R2656 a_15128_n19574.t0 a_15128_n19574.n0 24.2221
R2657 a_15128_n19574.n0 a_15128_n19574.n1 0.4955
R2658 a_15128_n19574.n1 a_15128_n19574.t2 15.7616
R2659 a_15128_n19574.n1 a_15128_n19574.t3 58.287
R2660 a_15128_n19574.n0 a_15128_n19574.t1 54.9754
R2661 a_2982_n17114.t2 a_2982_n17114.n0 14.9362
R2662 a_2982_n17114.n0 a_2982_n17114.n3 4.5005
R2663 a_2982_n17114.n3 a_2982_n17114.n2 18.338
R2664 a_2982_n17114.n2 a_2982_n17114.t3 40.9507
R2665 a_2982_n17114.n2 a_2982_n17114.t4 40.9463
R2666 a_2982_n17114.n3 a_2982_n17114.n1 8.789
R2667 a_2982_n17114.n1 a_2982_n17114.t1 10.5574
R2668 a_2982_n17114.n1 a_2982_n17114.t0 50.1712
R2669 a_2982_n17114.n0 a_2982_n17114.t5 50.6618
R2670 a_3336_n12918.t2 a_3336_n12918.n0 37.8095
R2671 a_3336_n12918.n0 a_3336_n12918.n1 3.0605
R2672 a_3336_n12918.n1 a_3336_n12918.n3 11.4867
R2673 a_3336_n12918.n3 a_3336_n12918.t4 4.76474
R2674 a_3336_n12918.n3 a_3336_n12918.n2 23.5353
R2675 a_3336_n12918.n2 a_3336_n12918.t3 0.303833
R2676 a_3336_n12918.n2 a_3336_n12918.t1 0.303833
R2677 a_3336_n12918.n1 a_3336_n12918.t5 61.5687
R2678 a_3336_n12918.n0 a_3336_n12918.t0 22.9358
R2679 a_25264_n12918.t0 a_25264_n12918.t1 23.3323
R2680 a_19812_n12918.t0 a_19812_n12918.t1 23.3323
R2681 a_13712_n12918.t0 a_13712_n12918.t1 23.3323
R2682 a_4728_n12918.t0 a_4728_n12918.t1 23.3323
R2683 a_21936_n12398.t0 a_21936_n12398.t1 23.3323
R2684 a_15736_n12398.t0 a_15736_n12398.t1 23.3323
R2685 a_9736_n12398.t0 a_9736_n12398.t1 23.3323
R2686 a_3336_n12398.t0 a_3336_n12398.t1 23.3323
R2687 a_17294_n17114.t0 a_17294_n17114.n0 33.008
R2688 a_17294_n17114.n0 a_17294_n17114.n1 19.508
R2689 a_17294_n17114.n1 a_17294_n17114.t2 21.2147
R2690 a_17294_n17114.n1 a_17294_n17114.t3 21.2102
R2691 a_17294_n17114.n0 a_17294_n17114.t1 28.688
R2692 a_19812_n11878.t0 a_19812_n11878.t1 23.3323
R2693 a_13712_n11878.t0 a_13712_n11878.t1 23.3323
R2694 a_4728_n11878.t0 a_4728_n11878.t1 23.3323
R2695 a_25264_n11438.t0 a_25264_n11438.t1 23.3323
R2696 a_15736_n11358.t0 a_15736_n11358.t1 23.3323
R2697 a_2920_n19634.t0 a_2920_n19634.n3 32.1665
R2698 a_2920_n19634.n1 a_2920_n19634.n0 2.95925
R2699 a_2920_n19634.n2 a_2920_n19634.n1 3.3755
R2700 a_2920_n19634.n3 a_2920_n19634.n2 3.3755
R2701 a_2920_n19634.n3 a_2920_n19634.t3 54.7215
R2702 a_2920_n19634.n2 a_2920_n19634.t4 41.0197
R2703 a_2920_n19634.n1 a_2920_n19634.t5 41.0215
R2704 a_2920_n19634.n0 a_2920_n19634.t2 20.6632
R2705 a_2920_n19634.n0 a_2920_n19634.t1 44.865
R2706 a_9736_n11358.t0 a_9736_n11358.t1 23.3323
R2707 a_3336_n11358.t0 a_3336_n11358.t1 23.3323
R2708 a_21936_n10918.t0 a_21936_n10918.t1 23.3323
R2709 a_10742_n10398.t1 a_10742_n10398.t0 56.264
R2710 a_9736_n10398.t1 a_9736_n10398.n0 40.208
R2711 a_9736_n10398.n0 a_9736_n10398.n1 7.45925
R2712 a_9736_n10398.n1 a_9736_n10398.n2 18.6418
R2713 a_9736_n10398.n2 a_9736_n10398.t3 33.7767
R2714 a_9736_n10398.n2 a_9736_n10398.t4 33.5202
R2715 a_9736_n10398.n1 a_9736_n10398.t2 16.7516
R2716 a_9736_n10398.n0 a_9736_n10398.t0 19.5961
R2717 a_4728_n10838.t0 a_4728_n10838.t1 23.3323
R2718 a_18870_n10398.t0 a_18870_n10398.t1 23.3323
R2719 a_11150_n9958.t3 a_11150_n9958.n1 36.6237
R2720 a_11150_n9958.n0 a_11150_n9958.t2 4.5005
R2721 a_11150_n9958.n1 a_11150_n9958.t1 10.6318
R2722 a_11150_n9958.n1 a_11150_n9958.n0 1.00175
R2723 a_11150_n9958.n0 a_11150_n9958.t0 11.633
R2724 a_9736_n9958.t2 a_9736_n9958.n1 40.0843
R2725 a_9736_n9958.n1 a_9736_n9958.n4 3.47675
R2726 a_9736_n9958.n4 a_9736_n9958.n5 27.3568
R2727 a_9736_n9958.n5 a_9736_n9958.t3 0.2735
R2728 a_9736_n9958.n5 a_9736_n9958.t4 0.2735
R2729 a_9736_n9958.n4 a_9736_n9958.n2 17.3142
R2730 a_9736_n9958.n2 a_9736_n9958.n3 0.2525
R2731 a_9736_n9958.n3 a_9736_n9958.t5 62.7592
R2732 a_9736_n9958.n3 a_9736_n9958.t6 62.5072
R2733 a_9736_n9958.n2 a_9736_n9958.t7 62.5072
R2734 a_9736_n9958.n1 a_9736_n9958.n0 16.3938
R2735 a_9736_n9958.n0 a_9736_n9958.t0 0.303833
R2736 a_9736_n9958.n0 a_9736_n9958.t1 0.303833
R2737 a_3336_n10318.t0 a_3336_n10318.t1 23.3323
R2738 a_15736_n9878.t0 a_15736_n9878.t1 23.3323
R2739 a_4728_n9798.t0 a_4728_n9798.t1 23.3323
R2740 a_3336_n9278.t0 a_3336_n9278.t1 23.3323
R2741 a_4728_n8758.t0 a_4728_n8758.t1 23.3323
R2742 a_3336_n8238.t0 a_3336_n8238.n0 34.349
R2743 a_3336_n8238.n0 a_3336_n8238.n2 1.823
R2744 a_3336_n8238.n2 a_3336_n8238.n1 15.413
R2745 a_3336_n8238.n1 a_3336_n8238.t3 21.2147
R2746 a_3336_n8238.n1 a_3336_n8238.t4 21.2102
R2747 a_3336_n8238.n0 a_3336_n8238.t1 29.5205
R2748 a_3336_n8238.n2 a_3336_n8238.t2 44.078
R2749 a_n8920_n7666.t0 a_n8920_n7666.n22 18.266
R2750 a_n8920_n7666.n22 a_n8920_n7666.n18 0.235143
R2751 a_n8920_n7666.n18 a_n8920_n7666.n20 0.527643
R2752 a_n8920_n7666.n20 a_n8920_n7666.n21 5.98978
R2753 a_n8920_n7666.n21 a_n8920_n7666.t6 0.379667
R2754 a_n8920_n7666.n21 a_n8920_n7666.t4 0.379667
R2755 a_n8920_n7666.n20 a_n8920_n7666.n19 5.51407
R2756 a_n8920_n7666.n19 a_n8920_n7666.t1 0.379667
R2757 a_n8920_n7666.n19 a_n8920_n7666.t3 0.379667
R2758 a_n8920_n7666.n18 a_n8920_n7666.t8 6.12657
R2759 a_n8920_n7666.n22 a_n8920_n7666.n17 0.608
R2760 a_n8920_n7666.n17 a_n8920_n7666.n16 5.00514
R2761 a_n8920_n7666.n16 a_n8920_n7666.n10 0.346289
R2762 a_n8920_n7666.n14 a_n8920_n7666.n15 0.187513
R2763 a_n8920_n7666.n13 a_n8920_n7666.n14 0.187513
R2764 a_n8920_n7666.n12 a_n8920_n7666.n13 0.187513
R2765 a_n8920_n7666.n11 a_n8920_n7666.n12 0.187513
R2766 a_n8920_n7666.n10 a_n8920_n7666.n11 0.187513
R2767 a_n8920_n7666.n15 a_n8920_n7666.t11 56.8107
R2768 a_n8920_n7666.n15 a_n8920_n7666.t13 56.6237
R2769 a_n8920_n7666.n14 a_n8920_n7666.t15 56.6237
R2770 a_n8920_n7666.n13 a_n8920_n7666.t17 56.6237
R2771 a_n8920_n7666.n12 a_n8920_n7666.t19 56.6237
R2772 a_n8920_n7666.n11 a_n8920_n7666.t21 56.6237
R2773 a_n8920_n7666.n10 a_n8920_n7666.t23 56.6237
R2774 a_n8920_n7666.n16 a_n8920_n7666.n9 0.213658
R2775 a_n8920_n7666.n7 a_n8920_n7666.n8 0.189974
R2776 a_n8920_n7666.n6 a_n8920_n7666.n7 0.189974
R2777 a_n8920_n7666.n5 a_n8920_n7666.n6 0.189974
R2778 a_n8920_n7666.n4 a_n8920_n7666.n5 0.189974
R2779 a_n8920_n7666.n3 a_n8920_n7666.n4 0.189974
R2780 a_n8920_n7666.n9 a_n8920_n7666.n3 0.144974
R2781 a_n8920_n7666.n8 a_n8920_n7666.t10 84.84
R2782 a_n8920_n7666.n8 a_n8920_n7666.t12 84.6505
R2783 a_n8920_n7666.n7 a_n8920_n7666.t14 84.6505
R2784 a_n8920_n7666.n6 a_n8920_n7666.t16 84.6505
R2785 a_n8920_n7666.n5 a_n8920_n7666.t18 84.6505
R2786 a_n8920_n7666.n4 a_n8920_n7666.t20 84.6505
R2787 a_n8920_n7666.n3 a_n8920_n7666.t22 84.6505
R2788 a_n8920_n7666.n9 a_n8920_n7666.t24 84.6505
R2789 a_n8920_n7666.n17 a_n8920_n7666.n1 2.21193
R2790 a_n8920_n7666.n1 a_n8920_n7666.n2 6.45885
R2791 a_n8920_n7666.n2 a_n8920_n7666.t5 0.5465
R2792 a_n8920_n7666.n2 a_n8920_n7666.t7 0.5465
R2793 a_n8920_n7666.n1 a_n8920_n7666.n0 5.98313
R2794 a_n8920_n7666.n0 a_n8920_n7666.t9 0.5465
R2795 a_n8920_n7666.n0 a_n8920_n7666.t2 0.5465
R2796 a_n9440_n5954.t0 a_n9440_n5954.t1 23.3323
R2797 a_n9960_n5954.t2 a_n9960_n5954.n3 32.3285
R2798 a_n9960_n5954.n3 a_n9960_n5954.n4 0.377079
R2799 a_n9960_n5954.n4 a_n9960_n5954.n13 0.192342
R2800 a_n9960_n5954.n11 a_n9960_n5954.n12 0.189974
R2801 a_n9960_n5954.n13 a_n9960_n5954.n11 0.144974
R2802 a_n9960_n5954.n12 a_n9960_n5954.t9 58.7685
R2803 a_n9960_n5954.n12 a_n9960_n5954.t11 58.5791
R2804 a_n9960_n5954.n11 a_n9960_n5954.t13 58.5791
R2805 a_n9960_n5954.n13 a_n9960_n5954.t15 58.5791
R2806 a_n9960_n5954.n4 a_n9960_n5954.n10 5.66086
R2807 a_n9960_n5954.n10 a_n9960_n5954.n8 1.42764
R2808 a_n9960_n5954.n8 a_n9960_n5954.n9 6.7395
R2809 a_n9960_n5954.n9 a_n9960_n5954.t1 0.701999
R2810 a_n9960_n5954.n9 a_n9960_n5954.t5 0.701999
R2811 a_n9960_n5954.n8 a_n9960_n5954.t7 7.29802
R2812 a_n9960_n5954.n10 a_n9960_n5954.n7 0.833
R2813 a_n9960_n5954.n7 a_n9960_n5954.n5 0.235143
R2814 a_n9960_n5954.n5 a_n9960_n5954.n6 6.02581
R2815 a_n9960_n5954.n6 a_n9960_n5954.t4 0.390639
R2816 a_n9960_n5954.n6 a_n9960_n5954.t3 0.390639
R2817 a_n9960_n5954.n5 a_n9960_n5954.t0 6.1289
R2818 a_n9960_n5954.n7 a_n9960_n5954.t6 19.9374
R2819 a_n9960_n5954.n3 a_n9960_n5954.t16 82.0434
R2820 a_n9960_n5954.n1 a_n9960_n5954.n2 0.189974
R2821 a_n9960_n5954.n0 a_n9960_n5954.n1 0.189974
R2822 a_n9960_n5954.n3 a_n9960_n5954.n0 0.142605
R2823 a_n9960_n5954.n2 a_n9960_n5954.t8 82.2328
R2824 a_n9960_n5954.n2 a_n9960_n5954.t10 82.0434
R2825 a_n9960_n5954.n1 a_n9960_n5954.t12 82.0434
R2826 a_n9960_n5954.n0 a_n9960_n5954.t14 82.0434
R2827 a_n9960_n5342.t0 a_n9960_n5342.t1 23.3323
R2828 a_n9440_n4694.t0 a_n9440_n4694.t1 23.3323
R2829 a_n9960_n4694.t3 a_n9960_n4694.n8 19.9374
R2830 a_n9960_n4694.n8 a_n9960_n4694.n7 6.12762
R2831 a_n9960_n4694.n7 a_n9960_n4694.t2 0.4555
R2832 a_n9960_n4694.n7 a_n9960_n4694.t0 0.4555
R2833 a_n9960_n4694.n8 a_n9960_n4694.n6 0.608
R2834 a_n9960_n4694.n6 a_n9960_n4694.n5 5.44871
R2835 a_n9960_n4694.n5 a_n9960_n4694.n3 0.470632
R2836 a_n9960_n4694.n3 a_n9960_n4694.n4 0.187513
R2837 a_n9960_n4694.n4 a_n9960_n4694.t6 50.0322
R2838 a_n9960_n4694.n4 a_n9960_n4694.t8 49.8451
R2839 a_n9960_n4694.n3 a_n9960_n4694.t10 49.8451
R2840 a_n9960_n4694.n5 a_n9960_n4694.n2 0.211289
R2841 a_n9960_n4694.n2 a_n9960_n4694.t5 32.0665
R2842 a_n9960_n4694.n2 a_n9960_n4694.n1 0.142605
R2843 a_n9960_n4694.n1 a_n9960_n4694.t7 80.5382
R2844 a_n9960_n4694.n1 a_n9960_n4694.t9 80.3487
R2845 a_n9960_n4694.n2 a_n9960_n4694.t11 80.3487
R2846 a_n9960_n4694.n6 a_n9960_n4694.n0 8.659
R2847 a_n9960_n4694.n0 a_n9960_n4694.t1 0.8195
R2848 a_n9960_n4694.n0 a_n9960_n4694.t4 0.8195
R2849 a_n9960_n3824.t0 a_n9960_n3824.t1 23.3323
R2850 a_n9440_n3176.t0 a_n9440_n3176.t1 23.3323
R2851 a_n9960_n3176.t2 a_n9960_n3176.n4 19.9374
R2852 a_n9960_n3176.n4 a_n9960_n3176.t0 6.36039
R2853 a_n9960_n3176.n4 a_n9960_n3176.n3 0.833
R2854 a_n9960_n3176.n3 a_n9960_n3176.n2 6.1205
R2855 a_n9960_n3176.n2 a_n9960_n3176.n1 0.429184
R2856 a_n9960_n3176.n1 a_n9960_n3176.t4 45.6878
R2857 a_n9960_n3176.n1 a_n9960_n3176.t6 45.5434
R2858 a_n9960_n3176.n2 a_n9960_n3176.n0 0.377079
R2859 a_n9960_n3176.n0 a_n9960_n3176.t3 32.7881
R2860 a_n9960_n3176.n0 a_n9960_n3176.t5 71.7569
R2861 a_n9960_n3176.n0 a_n9960_n3176.t7 71.6148
R2862 a_n9960_n3176.n3 a_n9960_n3176.t1 8.67406
R2863 a_n9960_n1788.t0 a_n9960_n1788.t1 23.3323
R2864 a_3032_n194.t3 a_3032_n194.n1 6.55061
R2865 a_3032_n194.n1 a_3032_n194.n51 30.1595
R2866 a_3032_n194.n50 a_3032_n194.n49 4.5005
R2867 a_3032_n194.n53 a_3032_n194.n54 4.5005
R2868 a_3032_n194.n58 a_3032_n194.n50 5.41898
R2869 a_3032_n194.n50 a_3032_n194.n53 6.3455
R2870 a_3032_n194.n51 a_3032_n194.n53 7.133
R2871 a_3032_n194.n56 a_3032_n194.n55 0.266516
R2872 a_3032_n194.n56 a_3032_n194.n57 0.237633
R2873 a_3032_n194.n61 a_3032_n194.n58 0.136529
R2874 a_3032_n194.n58 a_3032_n194.n57 0.816881
R2875 a_3032_n194.n57 a_3032_n194.n54 0.283447
R2876 a_3032_n194.n54 a_3032_n194.n55 0.257666
R2877 a_3032_n194.n55 a_3032_n194.n52 0.816753
R2878 a_3032_n194.n51 a_3032_n194.n52 4.64289
R2879 a_3032_n194.n61 a_3032_n194.t6 0.0646724
R2880 a_3032_n194.n60 a_3032_n194.n61 0.0223182
R2881 a_3032_n194.n60 a_3032_n194.t5 0.0646724
R2882 a_3032_n194.n60 a_3032_n194.n56 0.00266028
R2883 a_3032_n194.n59 a_3032_n194.n60 0.0223182
R2884 a_3032_n194.n59 a_3032_n194.t4 0.0646724
R2885 a_3032_n194.n52 a_3032_n194.n59 0.122079
R2886 a_3032_n194.n49 a_3032_n194.t0 26.4626
R2887 a_3032_n194.n49 a_3032_n194.n48 10.598
R2888 a_3032_n194.n3 a_3032_n194.n2 0.1805
R2889 a_3032_n194.n4 a_3032_n194.n3 0.1805
R2890 a_3032_n194.n5 a_3032_n194.n4 0.1805
R2891 a_3032_n194.n6 a_3032_n194.n5 0.1805
R2892 a_3032_n194.n7 a_3032_n194.n6 0.1805
R2893 a_3032_n194.n8 a_3032_n194.n7 0.1805
R2894 a_3032_n194.n9 a_3032_n194.n8 0.1805
R2895 a_3032_n194.n10 a_3032_n194.n9 0.1805
R2896 a_3032_n194.n11 a_3032_n194.n10 0.1805
R2897 a_3032_n194.n12 a_3032_n194.n11 0.1805
R2898 a_3032_n194.n13 a_3032_n194.n12 0.1805
R2899 a_3032_n194.n14 a_3032_n194.n13 0.1805
R2900 a_3032_n194.n15 a_3032_n194.n14 0.1805
R2901 a_3032_n194.n16 a_3032_n194.n15 0.1805
R2902 a_3032_n194.n17 a_3032_n194.n16 0.1805
R2903 a_3032_n194.n18 a_3032_n194.n17 0.1805
R2904 a_3032_n194.n19 a_3032_n194.n18 0.1805
R2905 a_3032_n194.n20 a_3032_n194.n19 0.1805
R2906 a_3032_n194.n21 a_3032_n194.n20 0.1805
R2907 a_3032_n194.n22 a_3032_n194.n21 0.1805
R2908 a_3032_n194.n23 a_3032_n194.n22 0.1805
R2909 a_3032_n194.n24 a_3032_n194.n23 0.1805
R2910 a_3032_n194.n48 a_3032_n194.n24 0.095
R2911 a_3032_n194.n48 a_3032_n194.n25 0.086
R2912 a_3032_n194.n25 a_3032_n194.n26 0.1805
R2913 a_3032_n194.n26 a_3032_n194.n27 0.1805
R2914 a_3032_n194.n27 a_3032_n194.n28 0.1805
R2915 a_3032_n194.n28 a_3032_n194.n29 0.1805
R2916 a_3032_n194.n29 a_3032_n194.n30 0.1805
R2917 a_3032_n194.n30 a_3032_n194.n31 0.1805
R2918 a_3032_n194.n31 a_3032_n194.n32 0.1805
R2919 a_3032_n194.n32 a_3032_n194.n33 0.1805
R2920 a_3032_n194.n33 a_3032_n194.n34 0.1805
R2921 a_3032_n194.n34 a_3032_n194.n35 0.1805
R2922 a_3032_n194.n35 a_3032_n194.n36 0.1805
R2923 a_3032_n194.n36 a_3032_n194.n37 0.1805
R2924 a_3032_n194.n37 a_3032_n194.n38 0.1805
R2925 a_3032_n194.n38 a_3032_n194.n39 0.1805
R2926 a_3032_n194.n39 a_3032_n194.n40 0.1805
R2927 a_3032_n194.n40 a_3032_n194.n41 0.1805
R2928 a_3032_n194.n41 a_3032_n194.n42 0.1805
R2929 a_3032_n194.n42 a_3032_n194.n43 0.1805
R2930 a_3032_n194.n43 a_3032_n194.n44 0.1805
R2931 a_3032_n194.n44 a_3032_n194.n45 0.1805
R2932 a_3032_n194.n45 a_3032_n194.n46 0.1805
R2933 a_3032_n194.n46 a_3032_n194.n47 0.1805
R2934 a_3032_n194.n47 a_3032_n194.t7 71.7948
R2935 a_3032_n194.n47 a_3032_n194.t8 71.6148
R2936 a_3032_n194.n46 a_3032_n194.t9 71.6148
R2937 a_3032_n194.n45 a_3032_n194.t10 71.6148
R2938 a_3032_n194.n44 a_3032_n194.t11 71.6148
R2939 a_3032_n194.n43 a_3032_n194.t12 71.6148
R2940 a_3032_n194.n42 a_3032_n194.t13 71.6148
R2941 a_3032_n194.n41 a_3032_n194.t14 71.6148
R2942 a_3032_n194.n40 a_3032_n194.t15 71.6148
R2943 a_3032_n194.n39 a_3032_n194.t16 71.6148
R2944 a_3032_n194.n38 a_3032_n194.t17 71.6148
R2945 a_3032_n194.n37 a_3032_n194.t18 71.6148
R2946 a_3032_n194.n36 a_3032_n194.t19 71.6148
R2947 a_3032_n194.n35 a_3032_n194.t20 71.6148
R2948 a_3032_n194.n34 a_3032_n194.t21 71.6148
R2949 a_3032_n194.n33 a_3032_n194.t22 71.6148
R2950 a_3032_n194.n32 a_3032_n194.t23 71.6148
R2951 a_3032_n194.n31 a_3032_n194.t24 71.6148
R2952 a_3032_n194.n30 a_3032_n194.t25 71.6148
R2953 a_3032_n194.n29 a_3032_n194.t26 71.6148
R2954 a_3032_n194.n28 a_3032_n194.t27 71.6148
R2955 a_3032_n194.n27 a_3032_n194.t28 71.6148
R2956 a_3032_n194.n26 a_3032_n194.t29 71.6148
R2957 a_3032_n194.n25 a_3032_n194.t30 71.6148
R2958 a_3032_n194.n24 a_3032_n194.t31 71.6148
R2959 a_3032_n194.n23 a_3032_n194.t32 71.6148
R2960 a_3032_n194.n22 a_3032_n194.t33 71.6148
R2961 a_3032_n194.n21 a_3032_n194.t34 71.6148
R2962 a_3032_n194.n20 a_3032_n194.t35 71.6148
R2963 a_3032_n194.n19 a_3032_n194.t36 71.6148
R2964 a_3032_n194.n18 a_3032_n194.t37 71.6148
R2965 a_3032_n194.n17 a_3032_n194.t38 71.6148
R2966 a_3032_n194.n16 a_3032_n194.t39 71.6148
R2967 a_3032_n194.n15 a_3032_n194.t40 71.6148
R2968 a_3032_n194.n14 a_3032_n194.t41 71.6148
R2969 a_3032_n194.n13 a_3032_n194.t42 71.6148
R2970 a_3032_n194.n12 a_3032_n194.t43 71.6148
R2971 a_3032_n194.n11 a_3032_n194.t44 71.6148
R2972 a_3032_n194.n10 a_3032_n194.t45 71.6148
R2973 a_3032_n194.n9 a_3032_n194.t46 71.6148
R2974 a_3032_n194.n8 a_3032_n194.t47 71.6148
R2975 a_3032_n194.n7 a_3032_n194.t48 71.6148
R2976 a_3032_n194.n6 a_3032_n194.t49 71.6148
R2977 a_3032_n194.n5 a_3032_n194.t50 71.6148
R2978 a_3032_n194.n4 a_3032_n194.t51 71.6148
R2979 a_3032_n194.n3 a_3032_n194.t52 71.6148
R2980 a_3032_n194.n2 a_3032_n194.t53 71.6148
R2981 a_3032_n194.n2 a_3032_n194.t54 71.7948
R2982 a_3032_n194.n1 a_3032_n194.n0 5.72261
R2983 a_3032_n194.n0 a_3032_n194.t1 0.20525
R2984 a_3032_n194.n0 a_3032_n194.t2 0.20525
R2985 a_n4939_n460.t0 a_n4939_n460.t1 22.3309
R2986 a_n3466_n200.t0 a_n3466_n200.t1 22.3309
R2987 a_n9440_n1140.t0 a_n9440_n1140.t1 23.3323
R2988 a_n9960_118.t0 a_n9960_118.t1 23.3323
R2989 a_n10480_n1140.t0 a_n10480_n1140.t1 23.3323
R2990 a_n11000_n1140.t0 a_n11000_n1140.n3 21.6089
R2991 a_n11000_n1140.n3 a_n11000_n1140.t2 6.76688
R2992 a_n11000_n1140.n3 a_n11000_n1140.n2 0.608
R2993 a_n11000_n1140.n2 a_n11000_n1140.n1 7.21014
R2994 a_n11000_n1140.n1 a_n11000_n1140.t4 52.5373
R2995 a_n11000_n1140.n1 a_n11000_n1140.n0 0.211289
R2996 a_n11000_n1140.n0 a_n11000_n1140.t1 33.8778
R2997 a_n11000_n1140.n0 a_n11000_n1140.t5 84.6505
R2998 a_n11000_n1140.n2 a_n11000_n1140.t3 9.88448
R2999 a_n11000_118.t0 a_n11000_118.t1 23.3323
R3000 a_n4939_60.t0 a_n4939_60.t1 22.3309
R3001 a_n9440_766.t0 a_n9440_766.t1 23.3323
R3002 a_n9960_1968.t0 a_n9960_1968.t1 23.3323
R3003 a_n10480_766.t0 a_n10480_766.t1 23.3323
R3004 a_n11000_1968.t0 a_n11000_1968.t1 23.3323
R3005 a_n11520_766.t0 a_n11520_766.t1 23.3323
R3006 a_n12040_766.t0 a_n12040_766.n0 33.6689
R3007 a_n12040_766.n0 a_n12040_766.n1 0.377079
R3008 a_n12040_766.n1 a_n12040_766.t4 40.8525
R3009 a_n12040_766.n1 a_n12040_766.n3 7.00121
R3010 a_n12040_766.n3 a_n12040_766.t1 14.7589
R3011 a_n12040_766.n3 a_n12040_766.n2 0.833
R3012 a_n12040_766.n2 a_n12040_766.t2 8.04269
R3013 a_n12040_766.n2 a_n12040_766.t3 23.2803
R3014 a_n12040_766.n0 a_n12040_766.t5 61.1862
R3015 a_n12040_1968.t0 a_n12040_1968.t1 23.3323
R3016 a_n4939_1760.t0 a_n4939_1760.t1 22.3309
R3017 a_n3466_2020.t0 a_n3466_2020.t1 22.3309
R3018 a_n4939_2280.t0 a_n4939_2280.t1 22.3309
R3019 a_n866_2740.t0 a_n866_2740.n0 9.41333
R3020 a_n866_2740.n0 a_n866_2740.t1 9.2118
R3021 a_n866_2740.n0 a_n866_2740.t2 9.3742
R3022 a_n1134_3368.t0 a_n1134_3368.n0 9.01615
R3023 a_n1134_3368.n0 a_n1134_3368.n1 1.10007
R3024 a_n1134_3368.n1 a_n1134_3368.t3 56.5567
R3025 a_n1134_3368.n1 a_n1134_3368.t1 45.5434
R3026 a_n1134_3368.n0 a_n1134_3368.t2 3.40583
R3027 a_n2218_3378.t1 a_n2218_3378.n0 9.02789
R3028 a_n2218_3378.n0 a_n2218_3378.n1 0.978761
R3029 a_n2218_3378.n1 a_n2218_3378.t3 72.0569
R3030 a_n2218_3378.n1 a_n2218_3378.t2 45.9621
R3031 a_n2218_3378.n0 a_n2218_3378.t0 3.39409
R3032 a_n1110_4884.t0 a_n1110_4884.t1 9.1005
R3033 a_2732_5244.t0 a_2732_5244.t1 5.8505
R3034 a_n1110_5052.t0 a_n1110_5052.t1 9.1005
R3035 a_2132_5252.t0 a_2132_5252.t1 5.8505
R3036 a_532_5244.t0 a_532_5244.t1 5.8505
R3037 a_n68_5252.t0 a_n68_5252.t1 5.8505
R3038 a_n1110_5220.t0 a_n1110_5220.t1 9.1005
R3039 a_n1110_5388.t0 a_n1110_5388.t1 9.1005
R3040 a_n1630_5384.t0 a_n1630_5384.t1 9.1005
R3041 a_n1110_5556.t0 a_n1110_5556.t1 9.1005
R3042 a_2672_5348.t1 a_2672_5348.n0 11.1781
R3043 a_2672_5348.n0 a_2672_5348.t2 27.9967
R3044 a_2672_5348.n0 a_2672_5348.t0 5.57145
R3045 a_3282_5984.t0 a_3282_5984.t1 3.2505
R3046 a_472_5348.t1 a_472_5348.n0 11.1781
R3047 a_472_5348.n0 a_472_5348.t2 27.9967
R3048 a_472_5348.n0 a_472_5348.t0 5.57145
R3049 a_1922_5998.t0 a_1922_5998.n0 11.1272
R3050 a_1922_5998.n0 a_1922_5998.t1 5.5871
R3051 a_1922_5998.n0 a_1922_5998.n1 5.20121
R3052 a_1922_5998.n1 a_1922_5998.t3 39.0221
R3053 a_1922_5998.n1 a_1922_5998.t2 31.9469
R3054 a_1082_5984.t0 a_1082_5984.t1 3.2505
R3055 a_n1170_5156.t0 a_n1170_5156.n0 10.8005
R3056 a_n1170_5156.n0 a_n1170_5156.t1 6.05863
R3057 a_n1170_5156.n0 a_n1170_5156.n6 9.0005
R3058 a_n1170_5156.n6 a_n1170_5156.n5 6.701
R3059 a_n1170_5156.n5 a_n1170_5156.t2 32.593
R3060 a_n1170_5156.n5 a_n1170_5156.t7 38.5719
R3061 a_n1170_5156.n6 a_n1170_5156.n4 0.49775
R3062 a_n1170_5156.n4 a_n1170_5156.n3 10.4382
R3063 a_n1170_5156.n3 a_n1170_5156.n2 1.18399
R3064 a_n1170_5156.n2 a_n1170_5156.t6 34.3028
R3065 a_n1170_5156.n2 a_n1170_5156.t3 30.5324
R3066 a_n1170_5156.n3 a_n1170_5156.n1 1.2155
R3067 a_n1170_5156.n1 a_n1170_5156.t8 34.9895
R3068 a_n1170_5156.n1 a_n1170_5156.t5 30.1998
R3069 a_n1170_5156.n4 a_n1170_5156.t4 34.7842
R3070 a_n278_5998.t1 a_n278_5998.n0 11.1272
R3071 a_n278_5998.n0 a_n278_5998.t0 5.5871
R3072 a_n278_5998.n0 a_n278_5998.n1 5.20121
R3073 a_n278_5998.n1 a_n278_5998.t3 39.0221
R3074 a_n278_5998.n1 a_n278_5998.t2 31.9469
R3075 a_n1690_5488.t1 a_n1690_5488.n0 13.2969
R3076 a_n1690_5488.n0 a_n1690_5488.n1 0.544413
R3077 a_n1690_5488.n1 a_n1690_5488.t3 21.7791
R3078 a_n1690_5488.n1 a_n1690_5488.t2 22.2917
R3079 a_n1690_5488.n0 a_n1690_5488.t0 9.53231
R3080 a_24874_6374.t0 a_24874_6374.t1 39.4631
R3081 a_n1145_6254.t0 a_n1145_6254.t1 5.05606
R3082 a_n2358_6180.t0 a_n2358_6180.t1 10.9468
R3083 a_n2418_6310.t0 a_n2418_6310.n0 13.3477
R3084 a_n2418_6310.n0 a_n2418_6310.n1 0.614848
R3085 a_n2418_6310.n1 a_n2418_6310.t3 35.2576
R3086 a_n2418_6310.n1 a_n2418_6310.t2 27.7991
R3087 a_n2418_6310.n0 a_n2418_6310.t1 13.3959
R3088 a_2218_7104.t0 a_2218_7104.t1 3.2505
R3089 a_n320_7104.t0 a_n320_7104.t1 3.2505
R3090 a_n2420_7104.t0 a_n2420_7104.t1 3.2505
R3091 a_3480_7836.t0 a_3480_7836.t1 5.8505
R3092 a_22018_6314.t0 a_22018_6314.n0 21.578
R3093 a_22018_6314.n0 a_22018_6314.n1 5.28125
R3094 a_22018_6314.n1 a_22018_6314.n2 1.96925
R3095 a_22018_6314.n2 a_22018_6314.n3 2.768
R3096 a_22018_6314.n3 a_22018_6314.t4 16.4019
R3097 a_22018_6314.n2 a_22018_6314.t5 16.4062
R3098 a_22018_6314.n1 a_22018_6314.t2 15.5598
R3099 a_22018_6314.n3 a_22018_6314.t3 27.8094
R3100 a_22018_6314.n0 a_22018_6314.t1 20.9559
R3101 a_2880_7844.t0 a_2880_7844.t1 5.8505
R3102 a_2218_7264.t1 a_2218_7264.n0 11.1781
R3103 a_2218_7264.n0 a_2218_7264.t2 27.9967
R3104 a_2218_7264.n0 a_2218_7264.t0 5.57145
R3105 a_2818_7194.t0 a_2818_7194.n0 11.1272
R3106 a_2818_7194.n0 a_2818_7194.t1 5.5871
R3107 a_2818_7194.n0 a_2818_7194.n1 5.20121
R3108 a_2818_7194.n1 a_2818_7194.t3 31.9469
R3109 a_2818_7194.n1 a_2818_7194.t2 39.0221
R3110 a_1550_7204.t1 a_1550_7204.n0 11.6086
R3111 a_1550_7204.n0 a_1550_7204.n2 10.0243
R3112 a_1550_7204.n2 a_1550_7204.n3 1.39941
R3113 a_1550_7204.n3 a_1550_7204.t2 34.9895
R3114 a_1550_7204.n3 a_1550_7204.t4 30.1998
R3115 a_1550_7204.n2 a_1550_7204.n1 1.0042
R3116 a_1550_7204.n1 a_1550_7204.t3 34.3028
R3117 a_1550_7204.n1 a_1550_7204.t5 30.5324
R3118 a_1550_7204.n0 a_1550_7204.t0 5.2255
R3119 a_n1170_5324.t0 a_n1170_5324.n0 11.6336
R3120 a_n1170_5324.n0 a_n1170_5324.n3 9.2525
R3121 a_n1170_5324.n3 a_n1170_5324.n6 9.61657
R3122 a_n1170_5324.n6 a_n1170_5324.n5 1.3955
R3123 a_n1170_5324.n5 a_n1170_5324.t5 34.3028
R3124 a_n1170_5324.n5 a_n1170_5324.t2 30.5324
R3125 a_n1170_5324.n6 a_n1170_5324.n4 1.00811
R3126 a_n1170_5324.n4 a_n1170_5324.t6 34.9895
R3127 a_n1170_5324.n4 a_n1170_5324.t3 30.1998
R3128 a_n1170_5324.n3 a_n1170_5324.n2 2.3405
R3129 a_n1170_5324.n2 a_n1170_5324.t4 39.1187
R3130 a_n1170_5324.n2 a_n1170_5324.n1 4.52407
R3131 a_n1170_5324.n1 a_n1170_5324.t8 32.5951
R3132 a_n1170_5324.n1 a_n1170_5324.t7 38.5719
R3133 a_n1170_5324.n0 a_n1170_5324.t1 5.2255
R3134 a_n2588_5202.t0 a_n2588_5202.n5 11.2955
R3135 a_n2588_5202.n5 a_n2588_5202.n0 0.712674
R3136 a_n2588_5202.n5 a_n2588_5202.n1 0.338627
R3137 a_n2588_5202.n1 a_n2588_5202.n3 13.7769
R3138 a_n2588_5202.n3 a_n2588_5202.n4 7.39062
R3139 a_n2588_5202.n4 a_n2588_5202.t2 32.548
R3140 a_n2588_5202.n4 a_n2588_5202.t4 39.0552
R3141 a_n2588_5202.n3 a_n2588_5202.n2 9.0005
R3142 a_n2588_5202.n2 a_n2588_5202.t3 23.5336
R3143 a_n2588_5202.n2 a_n2588_5202.t5 26.7067
R3144 a_n2588_5202.n1 a_n2588_5202.t1 5.2255
R3145 a_n2588_5202.n0 a_n2588_5202.t7 27.3491
R3146 a_n2588_5202.n0 a_n2588_5202.t6 34.6334
R3147 a_942_7836.t0 a_942_7836.t1 5.8505
R3148 a_342_7844.t0 a_342_7844.t1 5.8505
R3149 a_n320_7264.t0 a_n320_7264.n0 11.1781
R3150 a_n320_7264.n0 a_n320_7264.t2 27.9967
R3151 a_n320_7264.n0 a_n320_7264.t1 5.57145
R3152 a_n1158_7836.t0 a_n1158_7836.t1 5.8505
R3153 a_280_7194.t0 a_280_7194.n0 11.1272
R3154 a_280_7194.n0 a_280_7194.t1 5.5871
R3155 a_280_7194.n0 a_280_7194.n1 5.20121
R3156 a_280_7194.n1 a_280_7194.t3 31.9469
R3157 a_280_7194.n1 a_280_7194.t2 39.0221
R3158 a_n1158_7658.t0 a_n1158_7658.n0 10.8005
R3159 a_n1158_7658.n0 a_n1158_7658.t1 6.05863
R3160 a_n1158_7658.n0 a_n1158_7658.n1 5.54412
R3161 a_n1158_7658.n1 a_n1158_7658.t2 39.4494
R3162 a_n1158_7658.n1 a_n1158_7658.t3 31.7187
R3163 a_n1758_7844.t0 a_n1758_7844.t1 5.8505
R3164 a_n2420_7264.t1 a_n2420_7264.n0 11.1781
R3165 a_n2420_7264.n0 a_n2420_7264.t2 27.9967
R3166 a_n2420_7264.n0 a_n2420_7264.t0 5.57145
R3167 a_n1820_7194.t1 a_n1820_7194.n0 11.1272
R3168 a_n1820_7194.n0 a_n1820_7194.t0 5.5871
R3169 a_n1820_7194.n0 a_n1820_7194.n1 5.20121
R3170 a_n1820_7194.n1 a_n1820_7194.t3 31.9469
R3171 a_n1820_7194.n1 a_n1820_7194.t2 39.0221
R3172 a_n2556_7038.t0 a_n2556_7038.n2 11.1292
R3173 a_n2556_7038.n2 a_n2556_7038.n0 0.530717
R3174 a_n2556_7038.n0 a_n2556_7038.n1 15.4758
R3175 a_n2556_7038.n1 a_n2556_7038.t4 32.593
R3176 a_n2556_7038.n1 a_n2556_7038.t3 38.5719
R3177 a_n2556_7038.n0 a_n2556_7038.t2 5.2255
R3178 a_n2556_7038.n2 a_n2556_7038.t1 11.0744
R3179 a_26120_7990.t0 a_26120_7990.t1 23.3323
R3180 a_22272_8510.t0 a_22272_8510.t1 23.3323
R3181 a_26120_9030.t0 a_26120_9030.t1 23.3323
R3182 a_22272_9550.t0 a_22272_9550.t1 23.3323
R3183 a_26120_10070.t0 a_26120_10070.t1 23.3323
R3184 a_22272_10590.t0 a_22272_10590.t1 23.3323
R3185 a_26120_11110.t0 a_26120_11110.t1 23.3323
R3186 a_22272_11630.t0 a_22272_11630.t1 23.3323
R3187 a_26120_12150.t0 a_26120_12150.t1 23.3323
C0 VDD CP_IBIAS 1.33521f
C1 VDD CORE_CLK 5.94343f
C2 VDD VDD_VCO 28.2236f
C3 m2_11083_1223# DOUBLER_K 0.16626f
C4 CP_IBIAS m2_16645_5859# 0.06884f
C5 O4N DOUBLER_K 0.02762f
C6 MIM_TOP DOUBLER_K 0.50007f
C7 RF_DRV1 DOUBLER_K 0.01399f
C8 O1N DOUBLER_K 0.65913f
C9 VTUNE DOUBLER_K 0.12313f
C10 CP_IBIAS m1_16115_6049# 0.06316f
C11 O1P DOUBLER_K 0.63794f
C12 O4P O2N 0.10282f
C13 O3N O2N 0.13588f
C14 O3N O4P 0.19187f
C15 O2P O2N 0.60415f
C16 VDD m1_16115_6049# 1.14876f
C17 O4N O2N 0.27348f
C18 O2P O4P 0.446f
C19 O3P m2_11083_1223# 0.02479f
C20 D1 PA_DRAIN 1.02464f
C21 O2P O3N 0.48024f
C22 O4N O4P 0.80419f
C23 O3P O2N 0.28462f
C24 MIM_TOP m2_11083_1223# 0.68337f
C25 O3P O4P 0.16393f
C26 O4N O3N 0.21736f
C27 RF_DRV1 m2_11083_1223# 0.01067f
C28 O3P O3N 0.58197f
C29 O4N O2P 0.11072f
C30 O1N m2_11083_1223# 0.03573f
C31 VDD DOUBLER_K 0.01669f
C32 O3P O2P 0.19234f
C33 O1N O2N 0.54452f
C34 VTUNE m2_11083_1223# 0.06413f
C35 O3P O4N 0.08566f
C36 VTUNE O2N 0.18479f
C37 O1N O4P 0.28492f
C38 O1P m2_11083_1223# 0.02607f
C39 MIM_TOP O4N 0.01408f
C40 O1N O3N 0.34472f
C41 O1P O2N 0.03294f
C42 VTUNE O4P 0.12682f
C43 VTUNE O3N 0.10041f
C44 O1N O2P 0.40474f
C45 O1P O4P 0.51196f
C46 O1P O3N 0.40929f
C47 VTUNE O2P 0.11267f
C48 O1N O4N 0.28447f
C49 O1N O3P 0.39584f
C50 VTUNE O4N 0.15696f
C51 RF_DRV1 MIM_TOP 0.24858f
C52 O1P O2P 0.44372f
C53 m1_16115_6049# m2_16645_5859# 0.23885f
C54 O1P O4N 0.71531f
C55 VTUNE O3P 0.2297f
C56 O1N MIM_TOP 0.11896f
C57 VTUNE MIM_TOP 0.06843f
C58 O1P O3P 0.14113f
C59 VDD_VCO m2_11083_1223# 0.10137f
C60 O1P MIM_TOP 0.056f
C61 VDD_VCO O2N 0.69125f
C62 VTUNE RF_DRV1 0.06432f
C63 VDD m2_11083_1223# 1.27133f
C64 VDD_VCO O4P 0.8579f
C65 VTUNE O1N 0.16219f
C66 O1P O1N 1.68717f
C67 VDD_VCO O3N 0.89267f
C68 VDD VCTRL 0.01728f
C69 O1P VTUNE 0.14367f
C70 VDD_VCO O2P 1.01082f
C71 TAIL_BIAS m1_20475_6009# 0.13693f
C72 VDD D1 4.18067f
C73 VDD_VCO O4N 0.71521f
C74 CP_IBIAS m1_20475_6009# 0.45744f
C75 VDD_VCO O3P 0.99785f
C76 TAIL_BIAS O1N 0.05506f
C77 VDD O3P 0.01404f
C78 PRESCALED MC 0.09587f
C79 VDD MIM_TOP 0.37438f
C80 VDD m1_20475_6009# 0.52068f
C81 VDD RF_DRV1 1.0759f
C82 VDD_VCO O1N 0.98787f
C83 CORE_CLK O1P 0.07917f
C84 VDD O1N 0.08759f
C85 VDD_VCO VTUNE 0.33667f
C86 VDD_VCO O1P 1.11175f
C87 VDD VTUNE 0.33048f
C88 CORE_CLK PRESCALED 0.1131f
C89 CP_IBIAS TAIL_BIAS 0.21632f
C90 VDD O1P 0.09567f
C91 VDD MC 0.19878f
C92 VDD_VCO TAIL_BIAS 0.03833f
C93 VDD PRESCALED 0.65096f
C94 VDD TAIL_BIAS 4.6982f
C95 VCTRL VSS 8.60239f
C96 PA_DRAIN VSS 7.23872f
C97 D1 VSS 7.02858f
C98 O2N VSS 2.62745f
C99 O4P VSS 1.83193f
C100 O3N VSS 2.28486f
C101 O2P VSS 2.02906f
C102 O4N VSS 2.82264f
C103 O3P VSS 4.17305f
C104 MIM_TOP VSS 1.5179f
C105 RF_DRV1 VSS 4.03428f
C106 O1N VSS 4.16674f
C107 VTUNE VSS 7.3425f
C108 O1P VSS 3.91929f
C109 MC VSS 2.67823f
C110 PRESCALED VSS 6.12634f
C111 TAIL_BIAS VSS 29.73653f
C112 CP_IBIAS VSS 3.9353f
C113 CORE_CLK VSS 7.11213f
C114 VDD_VCO VSS 95.30023f
C115 VDD VSS 0.41666p
C116 DOUBLER_K VSS 2.49105f
C117 m3_14672_6380# VSS 0.32337f $ **FLOATING
C118 m2_11083_1223# VSS 5.27305f $ **FLOATING
C119 m2_16645_5859# VSS 1.68241f $ **FLOATING
C120 m1_20475_6009# VSS 1.26934f $ **FLOATING
C121 m1_16115_6049# VSS 1.16277f $ **FLOATING
C122 a_26120_11110.t0 VSS 0.01295f
C123 a_26120_11110.t1 VSS 0.01295f
C124 a_22272_10590.t0 VSS 0.01295f
C125 a_22272_10590.t1 VSS 0.01295f
C126 a_26120_10070.t0 VSS 0.01295f
C127 a_26120_10070.t1 VSS 0.01295f
C128 a_22272_9550.t0 VSS 0.01306f
C129 a_22272_9550.t1 VSS 0.01306f
C130 a_26120_9030.t0 VSS 0.01299f
C131 a_26120_9030.t1 VSS 0.01299f
C132 a_22272_8510.t0 VSS 0.01525f
C133 a_22272_8510.t1 VSS 0.01525f
C134 a_26120_7990.t0 VSS 0.01499f
C135 a_26120_7990.t1 VSS 0.01499f
C136 a_n2556_7038.t0 VSS 0.04636f
C137 a_n2556_7038.t1 VSS 0.04601f
C138 a_n2556_7038.n0 VSS 0.34724f
C139 a_n2556_7038.t2 VSS 0.08727f
C140 a_n2556_7038.n1 VSS 0.82564f
C141 a_n2556_7038.t3 VSS 0.0566f
C142 a_n2556_7038.t4 VSS 0.04275f
C143 a_n2556_7038.n2 VSS 0.17003f
C144 a_n1820_7194.t1 VSS 0.05423f
C145 a_n1820_7194.n0 VSS 0.27862f
C146 a_n1820_7194.t2 VSS 0.06774f
C147 a_n1820_7194.t3 VSS 0.04438f
C148 a_n1820_7194.n1 VSS 0.53898f
C149 a_n1820_7194.t0 VSS 0.11142f
C150 a_n2420_7264.t1 VSS 0.04353f
C151 a_n2420_7264.t0 VSS 0.08842f
C152 a_n2420_7264.n0 VSS 0.37209f
C153 a_n2420_7264.t2 VSS 0.03089f
C154 a_n1158_7658.t0 VSS 0.0538f
C155 a_n1158_7658.n0 VSS 0.29209f
C156 a_n1158_7658.t3 VSS 0.0444f
C157 a_n1158_7658.t2 VSS 0.07205f
C158 a_n1158_7658.n1 VSS 0.64589f
C159 a_n1158_7658.t1 VSS 0.1305f
C160 a_280_7194.t0 VSS 0.05769f
C161 a_280_7194.n0 VSS 0.29637f
C162 a_280_7194.t2 VSS 0.07206f
C163 a_280_7194.t3 VSS 0.04721f
C164 a_280_7194.n1 VSS 0.57332f
C165 a_280_7194.t1 VSS 0.11852f
C166 a_n320_7264.t0 VSS 0.04517f
C167 a_n320_7264.t1 VSS 0.09175f
C168 a_n320_7264.n0 VSS 0.38609f
C169 a_n320_7264.t2 VSS 0.03205f
C170 a_n2588_5202.t0 VSS 0.07294f
C171 a_n2588_5202.t6 VSS 0.0778f
C172 a_n2588_5202.t7 VSS 0.04534f
C173 a_n2588_5202.n0 VSS 0.40533f
C174 a_n2588_5202.t1 VSS 0.13357f
C175 a_n2588_5202.n1 VSS 0.43019f
C176 a_n2588_5202.n2 VSS 0.33311f
C177 a_n2588_5202.t5 VSS 0.0609f
C178 a_n2588_5202.t3 VSS 0.04207f
C179 a_n2588_5202.n3 VSS 1.64959f
C180 a_n2588_5202.n4 VSS 0.69762f
C181 a_n2588_5202.t4 VSS 0.10058f
C182 a_n2588_5202.t2 VSS 0.07734f
C183 a_n2588_5202.n5 VSS 0.23229f
C184 a_n1170_5324.t0 VSS 0.08446f
C185 a_n1170_5324.t1 VSS 0.14423f
C186 a_n1170_5324.n0 VSS 0.41837f
C187 a_n1170_5324.t7 VSS 0.09354f
C188 a_n1170_5324.n1 VSS 0.60976f
C189 a_n1170_5324.t8 VSS 0.07068f
C190 a_n1170_5324.n2 VSS 2.24198f
C191 a_n1170_5324.t4 VSS 0.28669f
C192 a_n1170_5324.n3 VSS 0.8829f
C193 a_n1170_5324.t3 VSS 0.0904f
C194 a_n1170_5324.t6 VSS 0.08627f
C195 a_n1170_5324.n4 VSS 0.99428f
C196 a_n1170_5324.t2 VSS 0.09884f
C197 a_n1170_5324.n5 VSS 0.97912f
C198 a_n1170_5324.t5 VSS 0.08246f
C199 a_n1170_5324.n6 VSS 0.29636f
C200 a_1550_7204.t1 VSS 0.10005f
C201 a_1550_7204.t0 VSS 0.17285f
C202 a_1550_7204.n0 VSS 0.7335f
C203 a_1550_7204.t5 VSS 0.11845f
C204 a_1550_7204.n1 VSS 1.12919f
C205 a_1550_7204.t3 VSS 0.09882f
C206 a_1550_7204.n2 VSS 0.68453f
C207 a_1550_7204.t4 VSS 0.10833f
C208 a_1550_7204.t2 VSS 0.10338f
C209 a_1550_7204.n3 VSS 1.23275f
C210 a_2818_7194.t0 VSS 0.05154f
C211 a_2818_7194.n0 VSS 0.26478f
C212 a_2818_7194.t2 VSS 0.06438f
C213 a_2818_7194.t3 VSS 0.04218f
C214 a_2818_7194.n1 VSS 0.51222f
C215 a_2818_7194.t1 VSS 0.10589f
C216 a_2218_7264.t1 VSS 0.04432f
C217 a_2218_7264.t0 VSS 0.09002f
C218 a_2218_7264.n0 VSS 0.37882f
C219 a_2218_7264.t2 VSS 0.03145f
C220 a_22018_6314.t0 VSS 0.14205f
C221 a_22018_6314.t1 VSS 1.23752f
C222 a_22018_6314.n0 VSS 0.76223f
C223 a_22018_6314.t3 VSS 1.35622f
C224 a_22018_6314.t2 VSS 0.62945f
C225 a_22018_6314.n1 VSS 0.55706f
C226 a_22018_6314.t5 VSS 1.42161f
C227 a_22018_6314.n2 VSS 0.87696f
C228 a_22018_6314.t4 VSS 1.42164f
C229 a_22018_6314.n3 VSS 1.49373f
C230 a_n2420_7104.t0 VSS 0.01843f
C231 a_n2420_7104.t1 VSS 0.01843f
C232 a_n320_7104.t0 VSS 0.0212f
C233 a_n320_7104.t1 VSS 0.0212f
C234 a_2218_7104.t0 VSS 0.01911f
C235 a_2218_7104.t1 VSS 0.01911f
C236 a_n2418_6310.t0 VSS 0.04695f
C237 a_n2418_6310.t1 VSS 0.04573f
C238 a_n2418_6310.n0 VSS 0.28617f
C239 a_n2418_6310.t2 VSS 0.05399f
C240 a_n2418_6310.t3 VSS 0.09115f
C241 a_n2418_6310.n1 VSS 0.63649f
C242 a_n2358_6180.t0 VSS 0.17337f
C243 a_n2358_6180.t1 VSS 0.17337f
C244 a_n1145_6254.t0 VSS 0.01107f
C245 a_n1145_6254.t1 VSS 0.01107f
C246 a_24874_6374.t0 VSS 0.62534f
C247 a_24874_6374.t1 VSS 0.61959f
C248 a_n1690_5488.t1 VSS 0.04298f
C249 a_n1690_5488.t0 VSS 0.0962f
C250 a_n1690_5488.n0 VSS 0.25756f
C251 a_n1690_5488.t2 VSS 0.04727f
C252 a_n1690_5488.t3 VSS 0.04486f
C253 a_n1690_5488.n1 VSS 0.41823f
C254 a_n278_5998.t1 VSS 0.05577f
C255 a_n278_5998.n0 VSS 0.2865f
C256 a_n278_5998.t2 VSS 0.04564f
C257 a_n278_5998.t3 VSS 0.06966f
C258 a_n278_5998.n1 VSS 0.55423f
C259 a_n278_5998.t0 VSS 0.11457f
C260 a_n1170_5156.t0 VSS 0.05242f
C261 a_n1170_5156.n0 VSS 0.2793f
C262 a_n1170_5156.t4 VSS 0.11426f
C263 a_n1170_5156.t5 VSS 0.06417f
C264 a_n1170_5156.t8 VSS 0.06124f
C265 a_n1170_5156.n1 VSS 0.71878f
C266 a_n1170_5156.t3 VSS 0.07017f
C267 a_n1170_5156.n2 VSS 0.68118f
C268 a_n1170_5156.t6 VSS 0.05854f
C269 a_n1170_5156.n3 VSS 0.24515f
C270 a_n1170_5156.n4 VSS 1.94667f
C271 a_n1170_5156.n5 VSS 0.57456f
C272 a_n1170_5156.t7 VSS 0.0664f
C273 a_n1170_5156.t2 VSS 0.05016f
C274 a_n1170_5156.n6 VSS 0.85414f
C275 a_n1170_5156.t1 VSS 0.12714f
C276 a_1082_5984.t0 VSS 0.02144f
C277 a_1082_5984.t1 VSS 0.02144f
C278 a_1922_5998.t0 VSS 0.05142f
C279 a_1922_5998.n0 VSS 0.26418f
C280 a_1922_5998.t2 VSS 0.04208f
C281 a_1922_5998.t3 VSS 0.06423f
C282 a_1922_5998.n1 VSS 0.51104f
C283 a_1922_5998.t1 VSS 0.10565f
C284 a_472_5348.t1 VSS 0.04404f
C285 a_472_5348.t0 VSS 0.08946f
C286 a_472_5348.n0 VSS 0.37643f
C287 a_472_5348.t2 VSS 0.03125f
C288 a_3282_5984.t0 VSS 0.02031f
C289 a_3282_5984.t1 VSS 0.02031f
C290 a_2672_5348.t1 VSS 0.04338f
C291 a_2672_5348.t0 VSS 0.08812f
C292 a_2672_5348.n0 VSS 0.37082f
C293 a_2672_5348.t2 VSS 0.03078f
C294 a_n2218_3378.t1 VSS 0.08218f
C295 a_n2218_3378.t0 VSS 0.15643f
C296 a_n2218_3378.n0 VSS 0.27143f
C297 a_n2218_3378.t2 VSS 0.07473f
C298 a_n2218_3378.t3 VSS 0.14349f
C299 a_n2218_3378.n1 VSS 0.2769f
C300 a_n1134_3368.t0 VSS 0.075f
C301 a_n1134_3368.t2 VSS 0.14341f
C302 a_n1134_3368.n0 VSS 0.25465f
C303 a_n1134_3368.t1 VSS 0.06805f
C304 a_n1134_3368.n1 VSS 0.42473f
C305 a_n1134_3368.t3 VSS 0.10882f
C306 a_n866_2740.t0 VSS 0.04372f
C307 a_n866_2740.t2 VSS 0.04353f
C308 a_n866_2740.t1 VSS 0.0428f
C309 a_n866_2740.n0 VSS 0.1303f
C310 a_n4939_2280.t0 VSS 0.02483f
C311 a_n4939_2280.t1 VSS 0.02483f
C312 a_n3466_2020.t0 VSS 0.06952f
C313 a_n3466_2020.t1 VSS 0.06952f
C314 a_n4939_1760.t0 VSS 0.03698f
C315 a_n4939_1760.t1 VSS 0.03698f
C316 a_n12040_1968.t0 VSS 0.01049f
C317 a_n12040_1968.t1 VSS 0.01049f
C318 a_n12040_766.t0 VSS 0.21233f
C319 a_n12040_766.n0 VSS 0.36908f
C320 a_n12040_766.t5 VSS 0.06933f
C321 a_n12040_766.n1 VSS 0.18411f
C322 a_n12040_766.t3 VSS 0.17112f
C323 a_n12040_766.t2 VSS 0.14284f
C324 a_n12040_766.n2 VSS 0.66196f
C325 a_n12040_766.t1 VSS 0.06651f
C326 a_n12040_766.n3 VSS 0.37499f
C327 a_n12040_766.t4 VSS 0.03717f
C328 a_n11520_766.t0 VSS 0.06173f
C329 a_n11520_766.t1 VSS 0.06173f
C330 a_n11000_1968.t0 VSS 0.01755f
C331 a_n11000_1968.t1 VSS 0.01755f
C332 a_n10480_766.t0 VSS 0.0631f
C333 a_n10480_766.t1 VSS 0.0631f
C334 a_n9960_1968.t0 VSS 0.02163f
C335 a_n9960_1968.t1 VSS 0.02163f
C336 a_n9440_766.t0 VSS 0.07029f
C337 a_n9440_766.t1 VSS 0.07029f
C338 a_n4939_60.t0 VSS 0.03025f
C339 a_n4939_60.t1 VSS 0.03025f
C340 a_n11000_118.t0 VSS 0.01993f
C341 a_n11000_118.t1 VSS 0.01993f
C342 a_n11000_n1140.t0 VSS 0.14124f
C343 a_n11000_n1140.t3 VSS 0.12936f
C344 a_n11000_n1140.t5 VSS 0.11262f
C345 a_n11000_n1140.n0 VSS 0.40227f
C346 a_n11000_n1140.t1 VSS 0.23153f
C347 a_n11000_n1140.t4 VSS 0.05859f
C348 a_n11000_n1140.n1 VSS 0.18598f
C349 a_n11000_n1140.n2 VSS 0.42085f
C350 a_n11000_n1140.t2 VSS 0.27125f
C351 a_n11000_n1140.n3 VSS 0.58701f
C352 a_n10480_n1140.t0 VSS 0.06157f
C353 a_n10480_n1140.t1 VSS 0.06157f
C354 a_n9960_118.t0 VSS 0.03298f
C355 a_n9960_118.t1 VSS 0.03298f
C356 a_n9440_n1140.t0 VSS 0.07007f
C357 a_n9440_n1140.t1 VSS 0.07007f
C358 a_n3466_n200.t0 VSS 0.02741f
C359 a_n3466_n200.t1 VSS 0.02741f
C360 a_n4939_n460.t0 VSS 0.02237f
C361 a_n4939_n460.t1 VSS 0.02237f
C362 a_3032_n194.t3 VSS 0.05896f
C363 a_3032_n194.n0 VSS 0.03732f
C364 a_3032_n194.n1 VSS 0.1701f
C365 a_3032_n194.n2 VSS 0.01261f
C366 a_3032_n194.n47 VSS 0.01261f
C367 a_3032_n194.t0 VSS 0.13821f
C368 a_3032_n194.n49 VSS 0.18608f
C369 a_3032_n194.n50 VSS 0.06225f
C370 a_3032_n194.n51 VSS 0.21873f
C371 a_3032_n194.n52 VSS 0.40408f
C372 a_3032_n194.n53 VSS 0.09769f
C373 a_3032_n194.n54 VSS 0.13857f
C374 a_3032_n194.n55 VSS 0.20103f
C375 a_3032_n194.n56 VSS 0.46222f
C376 a_3032_n194.n57 VSS 0.20747f
C377 a_3032_n194.n58 VSS 0.38768f
C378 a_3032_n194.t6 VSS 35.5697f
C379 a_3032_n194.n59 VSS 6.32301f
C380 a_3032_n194.t4 VSS 35.5697f
C381 a_3032_n194.n60 VSS 5.87771f
C382 a_3032_n194.t5 VSS 35.5697f
C383 a_3032_n194.n61 VSS 6.32962f
C384 a_n9960_n1788.t0 VSS 0.0248f
C385 a_n9960_n1788.t1 VSS 0.0248f
C386 a_n9960_n3176.t2 VSS 0.11498f
C387 a_n9960_n3176.t1 VSS 0.22545f
C388 a_n9960_n3176.t7 VSS 0.09713f
C389 a_n9960_n3176.t5 VSS 0.09726f
C390 a_n9960_n3176.n0 VSS 0.44663f
C391 a_n9960_n3176.t3 VSS 0.20989f
C392 a_n9960_n3176.t6 VSS 0.05032f
C393 a_n9960_n3176.t4 VSS 0.05048f
C394 a_n9960_n3176.n1 VSS 0.13406f
C395 a_n9960_n3176.n2 VSS 0.09841f
C396 a_n9960_n3176.n3 VSS 0.37595f
C397 a_n9960_n3176.t0 VSS 0.48824f
C398 a_n9960_n3176.n4 VSS 0.52146f
C399 a_n9440_n3176.t0 VSS 0.07013f
C400 a_n9440_n3176.t1 VSS 0.07013f
C401 a_n9960_n3824.t0 VSS 0.0267f
C402 a_n9960_n3824.t1 VSS 0.0267f
C403 a_n9960_n4694.t3 VSS 0.13872f
C404 a_n9960_n4694.t4 VSS 0.03509f
C405 a_n9960_n4694.t1 VSS 0.03509f
C406 a_n9960_n4694.n0 VSS 0.15172f
C407 a_n9960_n4694.t11 VSS 0.13587f
C408 a_n9960_n4694.t9 VSS 0.13587f
C409 a_n9960_n4694.n1 VSS 0.18573f
C410 a_n9960_n4694.t7 VSS 0.13609f
C411 a_n9960_n4694.n2 VSS 0.39277f
C412 a_n9960_n4694.t5 VSS 0.22323f
C413 a_n9960_n4694.n3 VSS 0.11718f
C414 a_n9960_n4694.t10 VSS 0.07015f
C415 a_n9960_n4694.t8 VSS 0.07015f
C416 a_n9960_n4694.n4 VSS 0.14312f
C417 a_n9960_n4694.t6 VSS 0.0704f
C418 a_n9960_n4694.n5 VSS 0.08829f
C419 a_n9960_n4694.n6 VSS 0.39932f
C420 a_n9960_n4694.t0 VSS 0.07018f
C421 a_n9960_n4694.t2 VSS 0.07018f
C422 a_n9960_n4694.n7 VSS 0.29176f
C423 a_n9960_n4694.n8 VSS 0.60004f
C424 a_n9440_n4694.t0 VSS 0.07171f
C425 a_n9440_n4694.t1 VSS 0.07171f
C426 a_n9960_n5342.t0 VSS 0.03021f
C427 a_n9960_n5342.t1 VSS 0.03021f
C428 a_n9960_n5954.t2 VSS 0.21367f
C429 a_n9960_n5954.t14 VSS 0.12738f
C430 a_n9960_n5954.n0 VSS 0.08846f
C431 a_n9960_n5954.t12 VSS 0.12738f
C432 a_n9960_n5954.n1 VSS 0.09314f
C433 a_n9960_n5954.t10 VSS 0.12738f
C434 a_n9960_n5954.n2 VSS 0.17627f
C435 a_n9960_n5954.t8 VSS 0.12757f
C436 a_n9960_n5954.n3 VSS 0.39472f
C437 a_n9960_n5954.t16 VSS 0.12738f
C438 a_n9960_n5954.n4 VSS 0.07368f
C439 a_n9960_n5954.t6 VSS 0.12647f
C440 a_n9960_n5954.t0 VSS 0.4941f
C441 a_n9960_n5954.n5 VSS 0.176f
C442 a_n9960_n5954.t3 VSS 0.07461f
C443 a_n9960_n5954.t4 VSS 0.07461f
C444 a_n9960_n5954.n6 VSS 0.31885f
C445 a_n9960_n5954.n7 VSS 0.48178f
C446 a_n9960_n5954.t7 VSS 0.20658f
C447 a_n9960_n5954.n8 VSS 0.22217f
C448 a_n9960_n5954.t5 VSS 0.03735f
C449 a_n9960_n5954.t1 VSS 0.03735f
C450 a_n9960_n5954.n9 VSS 0.13676f
C451 a_n9960_n5954.n10 VSS 0.25525f
C452 a_n9960_n5954.t15 VSS 0.08093f
C453 a_n9960_n5954.t13 VSS 0.08093f
C454 a_n9960_n5954.n11 VSS 0.07132f
C455 a_n9960_n5954.t11 VSS 0.08093f
C456 a_n9960_n5954.n12 VSS 0.14149f
C457 a_n9960_n5954.t9 VSS 0.08115f
C458 a_n9960_n5954.n13 VSS 0.08055f
C459 a_n9440_n5954.t0 VSS 0.07182f
C460 a_n9440_n5954.t1 VSS 0.07182f
C461 a_n8920_n7666.t0 VSS 0.09813f
C462 a_n8920_n7666.t2 VSS 0.04911f
C463 a_n8920_n7666.t9 VSS 0.04911f
C464 a_n8920_n7666.n0 VSS 0.18476f
C465 a_n8920_n7666.n1 VSS 0.24633f
C466 a_n8920_n7666.t7 VSS 0.04911f
C467 a_n8920_n7666.t5 VSS 0.04911f
C468 a_n8920_n7666.n2 VSS 0.18961f
C469 a_n8920_n7666.t24 VSS 0.13565f
C470 a_n8920_n7666.t22 VSS 0.13565f
C471 a_n8920_n7666.n3 VSS 0.09258f
C472 a_n8920_n7666.t20 VSS 0.13565f
C473 a_n8920_n7666.n4 VSS 0.09712f
C474 a_n8920_n7666.t18 VSS 0.13565f
C475 a_n8920_n7666.n5 VSS 0.09712f
C476 a_n8920_n7666.t16 VSS 0.13565f
C477 a_n8920_n7666.n6 VSS 0.09712f
C478 a_n8920_n7666.t14 VSS 0.13565f
C479 a_n8920_n7666.n7 VSS 0.09712f
C480 a_n8920_n7666.t12 VSS 0.13565f
C481 a_n8920_n7666.n8 VSS 0.184f
C482 a_n8920_n7666.t10 VSS 0.13584f
C483 a_n8920_n7666.n9 VSS 0.10417f
C484 a_n8920_n7666.n10 VSS 0.10151f
C485 a_n8920_n7666.t23 VSS 0.07908f
C486 a_n8920_n7666.t21 VSS 0.07908f
C487 a_n8920_n7666.n11 VSS 0.07669f
C488 a_n8920_n7666.t19 VSS 0.07908f
C489 a_n8920_n7666.n12 VSS 0.07669f
C490 a_n8920_n7666.t17 VSS 0.07908f
C491 a_n8920_n7666.n13 VSS 0.07669f
C492 a_n8920_n7666.t15 VSS 0.07908f
C493 a_n8920_n7666.n14 VSS 0.07669f
C494 a_n8920_n7666.t13 VSS 0.07908f
C495 a_n8920_n7666.n15 VSS 0.14299f
C496 a_n8920_n7666.t11 VSS 0.0793f
C497 a_n8920_n7666.n16 VSS 0.06257f
C498 a_n8920_n7666.n17 VSS 0.23276f
C499 a_n8920_n7666.t8 VSS 0.52189f
C500 a_n8920_n7666.n18 VSS 0.11978f
C501 a_n8920_n7666.t3 VSS 0.07858f
C502 a_n8920_n7666.t1 VSS 0.07858f
C503 a_n8920_n7666.n19 VSS 0.33003f
C504 a_n8920_n7666.n20 VSS 0.15004f
C505 a_n8920_n7666.t4 VSS 0.07858f
C506 a_n8920_n7666.t6 VSS 0.07858f
C507 a_n8920_n7666.n21 VSS 0.33524f
C508 a_n8920_n7666.n22 VSS 0.3288f
C509 a_3336_n8238.t0 VSS 0.9285f
C510 a_3336_n8238.t2 VSS 2.0516f
C511 a_3336_n8238.t1 VSS 0.61928f
C512 a_3336_n8238.n0 VSS 4.62914f
C513 a_3336_n8238.t4 VSS 1.48884f
C514 a_3336_n8238.t3 VSS 1.48898f
C515 a_3336_n8238.n1 VSS 1.61218f
C516 a_3336_n8238.n2 VSS 6.10612f
C517 a_4728_n8758.t0 VSS 0.03691f
C518 a_4728_n8758.t1 VSS 0.03691f
C519 a_3336_n9278.t0 VSS 0.04049f
C520 a_3336_n9278.t1 VSS 0.04049f
C521 a_4728_n9798.t0 VSS 0.0426f
C522 a_4728_n9798.t1 VSS 0.0426f
C523 a_15736_n9878.t0 VSS 0.02516f
C524 a_15736_n9878.t1 VSS 0.02516f
C525 a_3336_n10318.t0 VSS 0.04015f
C526 a_3336_n10318.t1 VSS 0.04015f
C527 a_9736_n9958.t2 VSS 1.98657f
C528 a_9736_n9958.t0 VSS 0.20641f
C529 a_9736_n9958.t1 VSS 0.20641f
C530 a_9736_n9958.n0 VSS 1.35026f
C531 a_9736_n9958.n1 VSS 7.06947f
C532 a_9736_n9958.t7 VSS 0.9923f
C533 a_9736_n9958.n2 VSS 1.17841f
C534 a_9736_n9958.t6 VSS 0.9923f
C535 a_9736_n9958.n3 VSS 0.93175f
C536 a_9736_n9958.t5 VSS 0.99422f
C537 a_9736_n9958.n4 VSS 6.30145f
C538 a_9736_n9958.t3 VSS 0.20641f
C539 a_9736_n9958.t4 VSS 0.20641f
C540 a_9736_n9958.n5 VSS 2.87926f
C541 a_11150_n9958.t3 VSS 0.331f
C542 a_11150_n9958.t0 VSS 9.46143f
C543 a_11150_n9958.n0 VSS 0.45047f
C544 a_11150_n9958.t2 VSS 9.27888f
C545 a_11150_n9958.t1 VSS 9.42678f
C546 a_11150_n9958.n1 VSS 1.11672f
C547 a_18870_n10398.t0 VSS 0.02891f
C548 a_18870_n10398.t1 VSS 0.02891f
C549 a_4728_n10838.t0 VSS 0.0447f
C550 a_4728_n10838.t1 VSS 0.0447f
C551 a_9736_n10398.t1 VSS 1.86059f
C552 a_9736_n10398.t0 VSS 2.76681f
C553 a_9736_n10398.n0 VSS 8.58438f
C554 a_9736_n10398.t2 VSS 2.36634f
C555 a_9736_n10398.n1 VSS 4.21257f
C556 a_9736_n10398.t4 VSS 1.25393f
C557 a_9736_n10398.t3 VSS 1.25818f
C558 a_9736_n10398.n2 VSS 1.6822f
C559 a_10742_n10398.t1 VSS 1.56739f
C560 a_10742_n10398.t0 VSS 14.8557f
C561 a_21936_n10918.t0 VSS 0.02266f
C562 a_21936_n10918.t1 VSS 0.02266f
C563 a_3336_n11358.t0 VSS 0.04277f
C564 a_3336_n11358.t1 VSS 0.04277f
C565 a_9736_n11358.t0 VSS 0.04692f
C566 a_9736_n11358.t1 VSS 0.04692f
C567 a_2920_n19634.t0 VSS 0.69484f
C568 a_2920_n19634.t1 VSS 1.05898f
C569 a_2920_n19634.t2 VSS 1.38379f
C570 a_2920_n19634.n0 VSS 3.4719f
C571 a_2920_n19634.t5 VSS 0.93357f
C572 a_2920_n19634.n1 VSS 2.68064f
C573 a_2920_n19634.t4 VSS 0.93358f
C574 a_2920_n19634.n2 VSS 2.75057f
C575 a_2920_n19634.t3 VSS 1.40188f
C576 a_2920_n19634.n3 VSS 4.17616f
C577 a_15736_n11358.t0 VSS 0.04319f
C578 a_15736_n11358.t1 VSS 0.04319f
C579 a_25264_n11438.t0 VSS 0.03476f
C580 a_25264_n11438.t1 VSS 0.03476f
C581 a_4728_n11878.t0 VSS 0.04805f
C582 a_4728_n11878.t1 VSS 0.04805f
C583 a_13712_n11878.t0 VSS 0.05306f
C584 a_13712_n11878.t1 VSS 0.05306f
C585 a_19812_n11878.t0 VSS 0.0544f
C586 a_19812_n11878.t1 VSS 0.0544f
C587 a_17294_n17114.t0 VSS 0.7952f
C588 a_17294_n17114.t1 VSS 0.58641f
C589 a_17294_n17114.n0 VSS 5.64108f
C590 a_17294_n17114.t3 VSS 1.51083f
C591 a_17294_n17114.t2 VSS 1.51097f
C592 a_17294_n17114.n1 VSS 1.84098f
C593 a_3336_n12398.t0 VSS 0.04347f
C594 a_3336_n12398.t1 VSS 0.04347f
C595 a_9736_n12398.t0 VSS 0.04424f
C596 a_9736_n12398.t1 VSS 0.04424f
C597 a_15736_n12398.t0 VSS 0.04039f
C598 a_15736_n12398.t1 VSS 0.04039f
C599 a_21936_n12398.t0 VSS 0.0462f
C600 a_21936_n12398.t1 VSS 0.0462f
C601 a_4728_n12918.t0 VSS 0.03817f
C602 a_4728_n12918.t1 VSS 0.03817f
C603 a_13712_n12918.t0 VSS 0.04317f
C604 a_13712_n12918.t1 VSS 0.04317f
C605 a_19812_n12918.t0 VSS 0.04376f
C606 a_19812_n12918.t1 VSS 0.04376f
C607 a_25264_n12918.t0 VSS 0.03828f
C608 a_25264_n12918.t1 VSS 0.03828f
C609 a_3336_n12918.t2 VSS 0.08623f
C610 a_3336_n12918.t0 VSS 0.19405f
C611 a_3336_n12918.n0 VSS 0.48324f
C612 a_3336_n12918.t5 VSS 0.14339f
C613 a_3336_n12918.n1 VSS 0.41293f
C614 a_3336_n12918.t3 VSS 0.01222f
C615 a_3336_n12918.t1 VSS 0.01222f
C616 a_3336_n12918.n2 VSS 0.14102f
C617 a_3336_n12918.n3 VSS 0.38798f
C618 a_3336_n12918.t4 VSS 37.4161f
C619 a_2982_n17114.t2 VSS 0.59734f
C620 a_2982_n17114.t5 VSS 1.13743f
C621 a_2982_n17114.n0 VSS 1.62173f
C622 a_2982_n17114.t0 VSS 1.13121f
C623 a_2982_n17114.t1 VSS 1.31264f
C624 a_2982_n17114.n1 VSS 1.04349f
C625 a_2982_n17114.t4 VSS 1.04527f
C626 a_2982_n17114.t3 VSS 1.04532f
C627 a_2982_n17114.n2 VSS 1.14944f
C628 a_2982_n17114.n3 VSS 2.0307f
C629 a_15128_n19574.t0 VSS 2.01518f
C630 a_15128_n19574.t1 VSS 1.21736f
C631 a_15128_n19574.n0 VSS 2.78108f
C632 a_15128_n19574.t3 VSS 1.27894f
C633 a_15128_n19574.t2 VSS 1.43917f
C634 a_15128_n19574.n1 VSS 1.80535f
C635 a_9934_n17054.t0 VSS 1.01534f
C636 a_9934_n17054.t5 VSS 1.028f
C637 a_9934_n17054.n0 VSS 0.79535f
C638 a_9934_n17054.t2 VSS 0.1955f
C639 a_9934_n17054.t4 VSS 0.1955f
C640 a_9934_n17054.n1 VSS 1.31778f
C641 a_9934_n17054.t1 VSS 1.01534f
C642 a_9934_n17054.t3 VSS 1.028f
C643 a_9934_n17054.n2 VSS 1.06238f
C644 a_9934_n17054.n3 VSS 2.84964f
C645 a_13714_n17054.t5 VSS 0.09677f
C646 a_13714_n17054.n0 VSS 0.48121f
C647 a_13714_n17054.t2 VSS 0.90299f
C648 a_13714_n17054.t4 VSS 0.89454f
C649 a_13714_n17054.n1 VSS 0.80475f
C650 a_13714_n17054.n2 VSS 0.28848f
C651 a_13714_n17054.t0 VSS 0.09677f
C652 a_13714_n17054.t1 VSS 0.09677f
C653 a_13714_n17054.n3 VSS 1.38771f
C654 a_13714_n17054.t7 VSS 0.89657f
C655 a_13714_n17054.t6 VSS 0.90062f
C656 a_13714_n17054.n4 VSS 0.96644f
C657 a_13714_n17054.n5 VSS 3.1613f
C658 a_13714_n17054.t3 VSS 0.09677f
C659 a_9124_n19574.t1 VSS 0.73821f
C660 a_9124_n19574.t2 VSS 1.21875f
C661 a_9124_n19574.n0 VSS 2.56532f
C662 a_9124_n19574.t0 VSS 1.32694f
C663 DOUBLER_K.t3 VSS 1.48865f
C664 DOUBLER_K.t2 VSS 0.08369f
C665 DOUBLER_K.n0 VSS 0.40535f
C666 VDD.n0 VSS 0.02081f
C667 VDD.n1 VSS 0.02255f
C668 VDD.n2 VSS 0.04212f
C669 VDD.n3 VSS 0.0451f
C670 VDD.n4 VSS 0.03007f
C671 VDD.n5 VSS 0.03007f
C672 VDD.t136 VSS 0.22312f
C673 VDD.t139 VSS 0.14139f
C674 VDD.t90 VSS 0.34308f
C675 VDD.n6 VSS 0.19982f
C676 VDD.t137 VSS 0.03599f
C677 VDD.t140 VSS 0.02695f
C678 VDD.n7 VSS 0.05535f
C679 VDD.t91 VSS 0.08562f
C680 VDD.n8 VSS 0.05771f
C681 VDD.n9 VSS 0.07103f
C682 VDD.n10 VSS 0.03007f
C683 VDD.n11 VSS 14.367f
C684 VDD.n12 VSS 0.14253f
C685 VDD.n13 VSS 0.05056f
C686 VDD.n14 VSS 0.03899f
C687 VDD.t101 VSS 0.01517f
C688 VDD.t206 VSS 0.01515f
C689 VDD.n15 VSS 0.0332f
C690 VDD.t28 VSS 0.01812f
C691 VDD.n16 VSS 0.06236f
C692 VDD.t99 VSS 0.01823f
C693 VDD.t148 VSS 0.01682f
C694 VDD.t111 VSS 0.02844f
C695 VDD.n17 VSS 0.05035f
C696 VDD.t63 VSS 0.01482f
C697 VDD.t62 VSS 0.16343f
C698 VDD.t94 VSS 0.35794f
C699 VDD.t96 VSS 0.26559f
C700 VDD.t95 VSS 0.44748f
C701 VDD.t100 VSS 0.11511f
C702 VDD.t178 VSS 0.20432f
C703 VDD.t158 VSS 0.09893f
C704 VDD.t41 VSS 0.12801f
C705 VDD.n19 VSS 0.05056f
C706 VDD.n20 VSS 0.05032f
C707 VDD.t79 VSS 0.01482f
C708 VDD.t154 VSS 0.09893f
C709 VDD.t61 VSS 0.09803f
C710 VDD.t29 VSS 0.03548f
C711 VDD.t151 VSS 0.33323f
C712 VDD.t152 VSS 0.01515f
C713 VDD.n21 VSS 0.05464f
C714 VDD.n22 VSS 0.10206f
C715 VDD.n23 VSS 0.13943f
C716 VDD.t30 VSS 0.01482f
C717 VDD.n24 VSS 0.03043f
C718 VDD.n25 VSS 0.21518f
C719 VDD.t104 VSS 0.2064f
C720 VDD.t105 VSS 0.01517f
C721 VDD.n26 VSS 0.02349f
C722 VDD.n27 VSS 0.06173f
C723 VDD.t155 VSS 0.01517f
C724 VDD.n28 VSS 0.03101f
C725 VDD.n29 VSS 0.06173f
C726 VDD.n30 VSS 0.23136f
C727 VDD.n31 VSS 0.21518f
C728 VDD.n32 VSS 0.02003f
C729 VDD.n33 VSS 0.03991f
C730 VDD.n34 VSS 0.37266f
C731 VDD.n35 VSS 0.03954f
C732 VDD.t159 VSS 0.01515f
C733 VDD.n36 VSS 0.04107f
C734 VDD.n37 VSS 0.10206f
C735 VDD.n38 VSS 0.20556f
C736 VDD.t27 VSS 0.05522f
C737 VDD.n39 VSS 0.99978f
C738 VDD.t67 VSS 0.19847f
C739 VDD.t147 VSS 0.23984f
C740 VDD.t191 VSS 0.13926f
C741 VDD.t110 VSS 0.09668f
C742 VDD.t98 VSS 0.25781f
C743 VDD.t97 VSS 0.01517f
C744 VDD.n40 VSS 0.02349f
C745 VDD.n41 VSS 0.22758f
C746 VDD.t180 VSS 0.01515f
C747 VDD.n42 VSS 0.05464f
C748 VDD.n43 VSS -0.16574f
C749 VDD.n44 VSS 0.02002f
C750 VDD.n45 VSS 0.03661f
C751 VDD.n46 VSS 0.11518f
C752 VDD.n47 VSS 0.10501f
C753 VDD.n48 VSS 0.10436f
C754 VDD.n49 VSS 0.0779f
C755 VDD.t179 VSS 0.01482f
C756 VDD.n50 VSS 0.02002f
C757 VDD.n51 VSS 0.03658f
C758 VDD.n52 VSS 0.05031f
C759 VDD.n53 VSS 0.02349f
C760 VDD.n54 VSS 0.27394f
C761 VDD.t32 VSS 0.01517f
C762 VDD.n55 VSS 0.03101f
C763 VDD.n56 VSS 0.27394f
C764 VDD.t26 VSS 0.09803f
C765 VDD.t174 VSS 0.03548f
C766 VDD.t162 VSS 0.09893f
C767 VDD.t31 VSS 0.09893f
C768 VDD.n57 VSS 0.21098f
C769 VDD.t175 VSS 0.01482f
C770 VDD.n58 VSS 0.03044f
C771 VDD.n59 VSS 0.12389f
C772 VDD.t163 VSS 0.01515f
C773 VDD.n60 VSS 0.04107f
C774 VDD.n61 VSS 0.03941f
C775 VDD.n62 VSS 0.02817f
C776 VDD.n63 VSS 0.0451f
C777 VDD.n64 VSS 0.03007f
C778 VDD.n65 VSS 0.76429f
C779 VDD.n66 VSS 0.45298f
C780 VDD.n67 VSS 0.01615f
C781 VDD.n68 VSS 0.02766f
C782 VDD.n69 VSS 0.02887f
C783 VDD.t144 VSS 0.01876f
C784 VDD.t40 VSS 0.01876f
C785 VDD.n70 VSS 0.06236f
C786 VDD.n71 VSS 0.04142f
C787 VDD.t38 VSS 0.01876f
C788 VDD.t177 VSS 0.01876f
C789 VDD.n72 VSS 0.06236f
C790 VDD.n73 VSS 0.04142f
C791 VDD.t57 VSS 0.21049f
C792 VDD.t58 VSS 0.09088f
C793 VDD.n74 VSS 0.01263f
C794 VDD.t2 VSS 0.21049f
C795 VDD.n75 VSS 0.01684f
C796 VDD.n76 VSS 0.04691f
C797 VDD.t52 VSS 0.01824f
C798 VDD.t3 VSS 0.01824f
C799 VDD.n78 VSS 0.06173f
C800 VDD.n79 VSS 0.22492f
C801 VDD.t85 VSS 0.07621f
C802 VDD.n80 VSS 0.07359f
C803 VDD.t50 VSS 0.08877f
C804 VDD.n81 VSS 0.07001f
C805 VDD.n82 VSS 0.01546f
C806 VDD.n83 VSS 0.04691f
C807 VDD.t56 VSS 0.07621f
C808 VDD.n84 VSS 0.01263f
C809 VDD.n85 VSS 0.39225f
C810 VDD.n86 VSS 0.01263f
C811 VDD.n87 VSS 0.06495f
C812 VDD.t69 VSS 0.09394f
C813 VDD.n88 VSS 0.0725f
C814 VDD.n89 VSS 0.41751f
C815 VDD.n90 VSS 0.01503f
C816 VDD.n91 VSS 0.02887f
C817 VDD.n92 VSS 0.01263f
C818 VDD.t189 VSS 0.21049f
C819 VDD.n93 VSS 0.01157f
C820 VDD.n94 VSS 0.02406f
C821 VDD.n95 VSS 0.01564f
C822 VDD.n96 VSS 0.41751f
C823 VDD.n97 VSS 0.01564f
C824 VDD.t115 VSS 0.03883f
C825 VDD.n98 VSS 0.24537f
C826 VDD.t114 VSS 0.23897f
C827 VDD.n99 VSS 0.36173f
C828 VDD.n100 VSS 0.01578f
C829 VDD.n101 VSS 0.01769f
C830 VDD.n103 VSS 0.01203f
C831 VDD.n104 VSS 0.13145f
C832 VDD.n105 VSS 0.02887f
C833 VDD.n106 VSS 0.02165f
C834 VDD.n107 VSS 0.02887f
C835 VDD.n108 VSS 0.01203f
C836 VDD.n110 VSS 0.41751f
C837 VDD.n111 VSS 0.21334f
C838 VDD.n112 VSS 0.41751f
C839 VDD.n114 VSS 0.01203f
C840 VDD.t190 VSS 0.06204f
C841 VDD.n115 VSS 0.06777f
C842 VDD.n116 VSS 0.01263f
C843 VDD.n117 VSS 0.05894f
C844 VDD.n118 VSS 0.02887f
C845 VDD.n119 VSS 0.05894f
C846 VDD.n120 VSS 0.01503f
C847 VDD.n121 VSS 0.01277f
C848 VDD.n122 VSS 0.4112f
C849 VDD.n123 VSS 0.41751f
C850 VDD.n125 VSS 0.01503f
C851 VDD.n127 VSS 0.01263f
C852 VDD.n128 VSS 0.02887f
C853 VDD.n129 VSS 0.02887f
C854 VDD.n130 VSS 0.02887f
C855 VDD.n131 VSS 0.01263f
C856 VDD.n132 VSS 0.01491f
C857 VDD.n134 VSS 0.41751f
C858 VDD.t68 VSS 0.21049f
C859 VDD.n135 VSS 0.23228f
C860 VDD.n136 VSS 0.01049f
C861 VDD.n137 VSS 0.01277f
C862 VDD.n138 VSS 0.01503f
C863 VDD.n139 VSS 0.06495f
C864 VDD.n140 VSS 0.02887f
C865 VDD.n141 VSS 0.02887f
C866 VDD.n142 VSS 0.01503f
C867 VDD.n144 VSS 0.41751f
C868 VDD.t84 VSS 0.10209f
C869 VDD.t55 VSS 0.1926f
C870 VDD.n145 VSS 0.31543f
C871 VDD.n147 VSS 0.07479f
C872 VDD.n150 VSS 0.05894f
C873 VDD.n151 VSS 0.04089f
C874 VDD.n152 VSS 0.01203f
C875 VDD.n154 VSS 0.41751f
C876 VDD.n155 VSS 0.2628f
C877 VDD.t49 VSS 0.13997f
C878 VDD.t51 VSS 0.15471f
C879 VDD.n156 VSS 0.08073f
C880 VDD.n158 VSS 0.03933f
C881 VDD.n159 VSS 0.01522f
C882 VDD.n160 VSS 0.04691f
C883 VDD.n161 VSS 0.04089f
C884 VDD.n162 VSS 0.02887f
C885 VDD.n163 VSS 0.04089f
C886 VDD.n164 VSS 0.01503f
C887 VDD.n166 VSS 0.40383f
C888 VDD.n167 VSS 0.36384f
C889 VDD.n169 VSS 0.0104f
C890 VDD.n170 VSS 0.07281f
C891 VDD.n172 VSS 0.08073f
C892 VDD.t143 VSS 0.11472f
C893 VDD.t39 VSS 0.16839f
C894 VDD.t37 VSS 0.09577f
C895 VDD.n173 VSS 0.20808f
C896 VDD.n174 VSS 0.0151f
C897 VDD.t87 VSS 0.09394f
C898 VDD.n175 VSS 0.0695f
C899 VDD.n176 VSS 0.04691f
C900 VDD.n177 VSS 0.02887f
C901 VDD.t167 VSS 0.01955f
C902 VDD.t165 VSS 0.01955f
C903 VDD.n179 VSS 0.06326f
C904 VDD.t86 VSS 0.08525f
C905 VDD.t166 VSS 0.16839f
C906 VDD.t164 VSS 0.12524f
C907 VDD.t120 VSS 0.08525f
C908 VDD.t125 VSS 0.01955f
C909 VDD.t123 VSS 0.01955f
C910 VDD.n181 VSS 0.06326f
C911 VDD.n182 VSS 0.04275f
C912 VDD.n183 VSS 0.01197f
C913 VDD.t121 VSS 0.01955f
C914 VDD.t201 VSS 0.01955f
C915 VDD.n184 VSS 0.06326f
C916 VDD.n185 VSS 0.04275f
C917 VDD.n186 VSS 0.02887f
C918 VDD.t199 VSS 0.09394f
C919 VDD.n187 VSS 0.08324f
C920 VDD.t200 VSS 0.16839f
C921 VDD.t198 VSS 0.19817f
C922 VDD.n188 VSS 0.32485f
C923 VDD.n189 VSS 0.01437f
C924 VDD.n190 VSS 0.06943f
C925 VDD.n191 VSS 0.02887f
C926 VDD.n194 VSS 0.08073f
C927 VDD.t122 VSS 0.16734f
C928 VDD.t124 VSS 0.12734f
C929 VDD.n195 VSS 0.08073f
C930 VDD.n197 VSS 0.04154f
C931 VDD.n198 VSS 0.01209f
C932 VDD.n199 VSS 0.04089f
C933 VDD.n200 VSS 0.05894f
C934 VDD.n201 VSS 0.01353f
C935 VDD.n202 VSS 0.01157f
C936 VDD.n203 VSS 0.34489f
C937 VDD.t176 VSS 0.21049f
C938 VDD.n204 VSS 0.08073f
C939 VDD.n206 VSS 0.01263f
C940 VDD.n207 VSS 0.01089f
C941 VDD.n208 VSS 0.03007f
C942 VDD.n209 VSS 0.06721f
C943 VDD.n210 VSS 0.92262f
C944 VDD.t157 VSS 0.03788f
C945 VDD.t156 VSS 0.19535f
C946 VDD.n211 VSS 0.53577f
C947 VDD.n212 VSS 1.63212f
C948 VDD.n213 VSS 1.48459f
C949 VDD.n214 VSS 1.70126f
C950 VDD.n215 VSS 0.98124f
C951 VDD.n216 VSS 0.03007f
C952 VDD.n217 VSS 0.03007f
C953 VDD.n218 VSS 0.0451f
C954 VDD.n219 VSS 0.0451f
C955 VDD.n220 VSS 0.12028f
C956 VDD.n221 VSS 0.12028f
C957 VDD.n222 VSS 1.42394f
C958 VDD.n223 VSS 2.98412f
C959 VDD.n224 VSS 0.15587f
C960 VDD.n225 VSS 0.03262f
C961 VDD.t141 VSS 0.41945f
C962 VDD.n226 VSS 0.65326f
C963 VDD.n227 VSS 0.03262f
C964 VDD.n228 VSS 0.6456f
C965 VDD.t102 VSS 0.70322f
C966 VDD.t103 VSS 0.13153f
C967 VDD.n229 VSS 0.14874f
C968 VDD.n230 VSS 0.31924f
C969 VDD.n231 VSS 0.03262f
C970 VDD.n232 VSS 0.03262f
C971 VDD.n233 VSS 0.65326f
C972 VDD.n234 VSS 0.52739f
C973 VDD.t153 VSS 0.32836f
C974 VDD.n235 VSS 0.45077f
C975 VDD.n236 VSS 0.04754f
C976 VDD.n237 VSS 0.03262f
C977 VDD.n238 VSS 0.03262f
C978 VDD.n239 VSS 0.65326f
C979 VDD.n240 VSS 0.55803f
C980 VDD.t215 VSS 0.36912f
C981 VDD.n241 VSS 2.57175f
C982 VDD.n242 VSS 0.05412f
C983 VDD.n243 VSS 0.11287f
C984 VDD.t216 VSS 0.03646f
C985 VDD.n244 VSS 0.11184f
C986 VDD.t142 VSS 0.13154f
C987 VDD.n245 VSS 0.14323f
C988 VDD.n246 VSS 5.20519f
C989 VDD.n247 VSS 5.92753f
C990 VDD.n248 VSS 0.03007f
C991 VDD.n249 VSS 0.04515f
C992 VDD.n250 VSS 0.02255f
C993 VDD.n251 VSS 1.21233f
C994 VDD.n252 VSS 13.6866f
C995 VDD.n253 VSS 0.08763f
C996 VDD.n254 VSS 0.49948f
C997 VDD.n255 VSS 0.70987f
C998 VDD.t145 VSS 0.51772f
C999 VDD.t207 VSS 0.56475f
C1000 VDD.n256 VSS 0.98187f
C1001 VDD.n257 VSS 1.35328f
C1002 VDD.n258 VSS 0.04465f
C1003 VDD.n259 VSS 1.35328f
C1004 VDD.n260 VSS 0.05198f
C1005 VDD.n261 VSS 1.35328f
C1006 VDD.n262 VSS 1.35328f
C1007 VDD.n263 VSS 0.04465f
C1008 VDD.t197 VSS 0.29117f
C1009 VDD.n264 VSS 0.17111f
C1010 VDD.n265 VSS 0.11679f
C1011 VDD.t81 VSS 0.2908f
C1012 VDD.n266 VSS 0.17148f
C1013 VDD.n267 VSS 0.12268f
C1014 VDD.n268 VSS 0.04465f
C1015 VDD.n269 VSS 1.35328f
C1016 VDD.n270 VSS 0.85807f
C1017 VDD.t78 VSS 0.52574f
C1018 VDD.t64 VSS 0.49521f
C1019 VDD.n271 VSS 0.82754f
C1020 VDD.n272 VSS 0.04465f
C1021 VDD.n273 VSS 0.75631f
C1022 VDD.n274 VSS 0.04465f
C1023 VDD.n275 VSS 0.09033f
C1024 VDD.n276 VSS 0.04465f
C1025 VDD.t130 VSS 0.42398f
C1026 VDD.t42 VSS 0.59697f
C1027 VDD.n277 VSS 0.9293f
C1028 VDD.n278 VSS 1.35328f
C1029 VDD.n279 VSS 0.04465f
C1030 VDD.t65 VSS 0.67837f
C1031 VDD.n280 VSS 0.04465f
C1032 VDD.n281 VSS 1.01918f
C1033 VDD.n282 VSS 0.04465f
C1034 VDD.t119 VSS 0.22466f
C1035 VDD.t66 VSS 0.22244f
C1036 VDD.n283 VSS 0.16317f
C1037 VDD.n284 VSS 0.13267f
C1038 VDD.t117 VSS 0.29225f
C1039 VDD.n285 VSS 0.1918f
C1040 VDD.n286 VSS 0.04465f
C1041 VDD.t160 VSS 0.67837f
C1042 VDD.n287 VSS 1.00901f
C1043 VDD.n288 VSS 1.35328f
C1044 VDD.n289 VSS 0.04465f
C1045 VDD.n290 VSS 0.64089f
C1046 VDD.t116 VSS 0.75799f
C1047 VDD.n291 VSS 1.16843f
C1048 VDD.n292 VSS 1.35328f
C1049 VDD.n293 VSS 0.04465f
C1050 VDD.n294 VSS 0.05198f
C1051 VDD.n295 VSS 0.10958f
C1052 VDD.t161 VSS 0.29143f
C1053 VDD.n296 VSS 0.13476f
C1054 VDD.t138 VSS 0.04319f
C1055 VDD.n297 VSS 0.27664f
C1056 VDD.t135 VSS 0.04319f
C1057 VDD.n298 VSS 0.45308f
C1058 VDD.n299 VSS 0.10201f
C1059 VDD.n300 VSS 0.01582f
C1060 VDD.n301 VSS 0.02174f
C1061 VDD.t129 VSS 0.01564f
C1062 VDD.t77 VSS 0.01564f
C1063 VDD.n302 VSS 0.03987f
C1064 VDD.t214 VSS 0.01564f
C1065 VDD.t93 VSS 0.01564f
C1066 VDD.n303 VSS 0.03987f
C1067 VDD.n304 VSS 0.03516f
C1068 VDD.n305 VSS 0.05086f
C1069 VDD.n306 VSS 0.01133f
C1070 VDD.n307 VSS 0.05086f
C1071 VDD.n308 VSS 0.0866f
C1072 VDD.n309 VSS 0.0866f
C1073 VDD.n310 VSS 0.01133f
C1074 VDD.n311 VSS 0.01133f
C1075 VDD.n312 VSS 0.01133f
C1076 VDD.n313 VSS 0.01133f
C1077 VDD.n314 VSS 0.01133f
C1078 VDD.n315 VSS 0.05086f
C1079 VDD.n316 VSS 0.01852f
C1080 VDD.n317 VSS 0.01133f
C1081 VDD.t127 VSS 0.01564f
C1082 VDD.t54 VSS 0.01564f
C1083 VDD.n318 VSS 0.03632f
C1084 VDD.n319 VSS 0.02744f
C1085 VDD.n320 VSS 0.02174f
C1086 VDD.n321 VSS 0.03954f
C1087 VDD.n322 VSS 0.21643f
C1088 VDD.t11 VSS 0.01564f
C1089 VDD.t7 VSS 0.01564f
C1090 VDD.n323 VSS 0.03632f
C1091 VDD.n324 VSS 0.02744f
C1092 VDD.n325 VSS 0.0264f
C1093 VDD.t89 VSS 0.01564f
C1094 VDD.t13 VSS 0.01564f
C1095 VDD.n326 VSS 0.03632f
C1096 VDD.n327 VSS 0.02744f
C1097 VDD.n328 VSS 0.0264f
C1098 VDD.t1 VSS 0.01564f
C1099 VDD.t25 VSS 0.01564f
C1100 VDD.n329 VSS 0.03632f
C1101 VDD.n330 VSS 0.02744f
C1102 VDD.n331 VSS 0.0264f
C1103 VDD.t48 VSS 0.01564f
C1104 VDD.t5 VSS 0.01564f
C1105 VDD.n332 VSS 0.03632f
C1106 VDD.n333 VSS 0.02744f
C1107 VDD.n334 VSS 0.0264f
C1108 VDD.t193 VSS 0.01564f
C1109 VDD.t113 VSS 0.01564f
C1110 VDD.n335 VSS 0.03632f
C1111 VDD.n336 VSS 0.02744f
C1112 VDD.n337 VSS 0.0264f
C1113 VDD.n338 VSS 0.21643f
C1114 VDD.n339 VSS 0.02174f
C1115 VDD.t21 VSS 0.01564f
C1116 VDD.t169 VSS 0.01564f
C1117 VDD.n340 VSS 0.03632f
C1118 VDD.n341 VSS 0.01133f
C1119 VDD.n342 VSS 0.05086f
C1120 VDD.n343 VSS 0.0866f
C1121 VDD.n344 VSS 0.01133f
C1122 VDD.n345 VSS 0.01133f
C1123 VDD.n346 VSS 0.01133f
C1124 VDD.n347 VSS 0.01133f
C1125 VDD.n348 VSS 0.01133f
C1126 VDD.n349 VSS 0.05086f
C1127 VDD.n350 VSS 0.04003f
C1128 VDD.n351 VSS 0.01133f
C1129 VDD.t186 VSS 0.01564f
C1130 VDD.t134 VSS 0.01564f
C1131 VDD.n352 VSS 0.03632f
C1132 VDD.n353 VSS 0.02744f
C1133 VDD.n354 VSS 0.0264f
C1134 VDD.n355 VSS 0.01549f
C1135 VDD.t132 VSS 0.01564f
C1136 VDD.t188 VSS 0.01564f
C1137 VDD.n356 VSS 0.03632f
C1138 VDD.n357 VSS 0.02744f
C1139 VDD.n358 VSS 0.0264f
C1140 VDD.n359 VSS 0.0264f
C1141 VDD.t36 VSS 0.01564f
C1142 VDD.t34 VSS 0.01564f
C1143 VDD.n360 VSS 0.03632f
C1144 VDD.n361 VSS 0.02744f
C1145 VDD.n362 VSS 0.01133f
C1146 VDD.t19 VSS 0.01564f
C1147 VDD.t15 VSS 0.01564f
C1148 VDD.n363 VSS 0.03632f
C1149 VDD.n364 VSS 0.02744f
C1150 VDD.n365 VSS 0.0264f
C1151 VDD.t107 VSS 0.01564f
C1152 VDD.t150 VSS 0.01564f
C1153 VDD.n366 VSS 0.03632f
C1154 VDD.n367 VSS 0.02744f
C1155 VDD.n368 VSS 0.0264f
C1156 VDD.t60 VSS 0.01564f
C1157 VDD.t182 VSS 0.01564f
C1158 VDD.n369 VSS 0.03632f
C1159 VDD.n370 VSS 0.02744f
C1160 VDD.n371 VSS 0.0264f
C1161 VDD.t46 VSS 0.01564f
C1162 VDD.t173 VSS 0.01564f
C1163 VDD.n372 VSS 0.03632f
C1164 VDD.n373 VSS 0.02744f
C1165 VDD.n374 VSS 0.0264f
C1166 VDD.t171 VSS 0.01564f
C1167 VDD.t109 VSS 0.01564f
C1168 VDD.n375 VSS 0.03632f
C1169 VDD.n376 VSS 0.02744f
C1170 VDD.n377 VSS 0.0264f
C1171 VDD.t17 VSS 0.05774f
C1172 VDD.n378 VSS 0.01133f
C1173 VDD.n379 VSS 0.05292f
C1174 VDD.n380 VSS 0.0264f
C1175 VDD.n381 VSS 10.2134f
C1176 VDD.n382 VSS 0.22653f
C1177 VDD.n383 VSS 0.21643f
C1178 VDD.n384 VSS 0.21643f
C1179 VDD.n385 VSS 0.21643f
C1180 VDD.n386 VSS 0.21643f
C1181 VDD.n387 VSS 0.21643f
C1182 VDD.n388 VSS 0.21643f
C1183 VDD.n389 VSS 0.21643f
C1184 VDD.n390 VSS 0.21643f
C1185 VDD.n391 VSS 0.0264f
C1186 VDD.t205 VSS 0.01564f
C1187 VDD.t203 VSS 0.01564f
C1188 VDD.n392 VSS 0.03632f
C1189 VDD.n393 VSS 0.02744f
C1190 VDD.n394 VSS 0.01133f
C1191 VDD.t73 VSS 0.01564f
C1192 VDD.t23 VSS 0.01564f
C1193 VDD.n395 VSS 0.03632f
C1194 VDD.n396 VSS 0.02744f
C1195 VDD.n397 VSS 0.0264f
C1196 VDD.n398 VSS 0.02174f
C1197 VDD.n399 VSS 0.02174f
C1198 VDD.n400 VSS 0.02174f
C1199 VDD.n401 VSS 0.02174f
C1200 VDD.n402 VSS 0.02174f
C1201 VDD.n403 VSS 0.02174f
C1202 VDD.n404 VSS 0.02174f
C1203 VDD.n405 VSS 0.02174f
C1204 VDD.n406 VSS 0.02174f
C1205 VDD.n407 VSS 0.0227f
C1206 VDD.n408 VSS 0.01133f
C1207 VDD.n409 VSS 0.05302f
C1208 VDD.n410 VSS 0.05086f
C1209 VDD.n411 VSS 0.13586f
C1210 VDD.n412 VSS 0.0866f
C1211 VDD.n413 VSS 0.05086f
C1212 VDD.n414 VSS 0.05086f
C1213 VDD.n415 VSS 0.05086f
C1214 VDD.n416 VSS 0.05086f
C1215 VDD.n417 VSS 0.05086f
C1216 VDD.n418 VSS 0.0866f
C1217 VDD.n419 VSS 0.0866f
C1218 VDD.n420 VSS 0.05086f
C1219 VDD.n421 VSS 0.05086f
C1220 VDD.n422 VSS 0.01133f
C1221 VDD.n423 VSS 0.02744f
C1222 VDD.n424 VSS 0.0264f
C1223 VDD.n425 VSS 0.4185f
C1224 VDD.t75 VSS 0.01564f
C1225 VDD.t71 VSS 0.01564f
C1226 VDD.n426 VSS 0.03632f
C1227 VDD.n427 VSS 0.02744f
C1228 VDD.n428 VSS 0.0264f
C1229 VDD.n429 VSS 0.4185f
C1230 VDD.n430 VSS 0.21643f
C1231 VDD.n431 VSS 0.21643f
C1232 VDD.n432 VSS 0.21643f
C1233 VDD.n433 VSS 0.21643f
C1234 VDD.n434 VSS 0.21643f
C1235 VDD.n435 VSS 0.0264f
C1236 VDD.t44 VSS 0.01564f
C1237 VDD.t195 VSS 0.01564f
C1238 VDD.n436 VSS 0.03632f
C1239 VDD.n437 VSS 0.02744f
C1240 VDD.n438 VSS 0.01133f
C1241 VDD.n439 VSS 0.02174f
C1242 VDD.n440 VSS 0.02174f
C1243 VDD.n441 VSS 0.02174f
C1244 VDD.n442 VSS 0.02174f
C1245 VDD.n443 VSS 0.02174f
C1246 VDD.n444 VSS 0.02174f
C1247 VDD.n445 VSS 0.02174f
C1248 VDD.t83 VSS 0.01564f
C1249 VDD.t184 VSS 0.01564f
C1250 VDD.n446 VSS 0.03632f
C1251 VDD.n447 VSS 0.01133f
C1252 VDD.n448 VSS 0.02744f
C1253 VDD.n449 VSS 0.0264f
C1254 VDD.n450 VSS 0.21643f
C1255 VDD.t212 VSS 0.01564f
C1256 VDD.t210 VSS 0.01564f
C1257 VDD.n451 VSS 0.03632f
C1258 VDD.n452 VSS 0.02744f
C1259 VDD.n453 VSS 0.0264f
C1260 VDD.n454 VSS 0.21643f
C1261 VDD.t9 VSS 0.05774f
C1262 VDD.n455 VSS 0.01133f
C1263 VDD.n456 VSS 0.05292f
C1264 VDD.n457 VSS 0.02662f
C1265 VDD.n458 VSS 0.3758f
C1266 VDD.n459 VSS 0.0264f
C1267 VDD.n460 VSS 0.0227f
C1268 VDD.n461 VSS 0.01133f
C1269 VDD.n462 VSS 0.03503f
C1270 VDD.t10 VSS 0.15172f
C1271 VDD.n463 VSS 0.03503f
C1272 VDD.t74 VSS 0.15172f
C1273 VDD.n464 VSS 0.03503f
C1274 VDD.t170 VSS 0.15172f
C1275 VDD.n465 VSS 0.05223f
C1276 VDD.t16 VSS 0.46663f
C1277 VDD.t185 VSS 0.20399f
C1278 VDD.t133 VSS 0.20399f
C1279 VDD.t131 VSS 0.15172f
C1280 VDD.n466 VSS 0.09952f
C1281 VDD.t187 VSS 0.15427f
C1282 VDD.t35 VSS 0.20399f
C1283 VDD.t33 VSS 0.20399f
C1284 VDD.t18 VSS 0.15172f
C1285 VDD.n467 VSS 0.09853f
C1286 VDD.t14 VSS 0.15427f
C1287 VDD.t106 VSS 0.20399f
C1288 VDD.t149 VSS 0.20399f
C1289 VDD.t59 VSS 0.15172f
C1290 VDD.t172 VSS 0.20399f
C1291 VDD.t45 VSS 0.20399f
C1292 VDD.t181 VSS 0.15427f
C1293 VDD.n468 VSS 0.09853f
C1294 VDD.n469 VSS 0.03503f
C1295 VDD.n470 VSS 0.03503f
C1296 VDD.n471 VSS 0.09853f
C1297 VDD.t108 VSS 0.15427f
C1298 VDD.t204 VSS 0.20399f
C1299 VDD.t202 VSS 0.20399f
C1300 VDD.t72 VSS 0.15172f
C1301 VDD.n472 VSS 0.09853f
C1302 VDD.t22 VSS 0.15427f
C1303 VDD.t20 VSS 0.20399f
C1304 VDD.t168 VSS 0.20399f
C1305 VDD.t213 VSS 0.15172f
C1306 VDD.t76 VSS 0.20399f
C1307 VDD.t128 VSS 0.20399f
C1308 VDD.t92 VSS 0.15427f
C1309 VDD.n473 VSS 0.09853f
C1310 VDD.n474 VSS 0.03503f
C1311 VDD.n475 VSS 0.03503f
C1312 VDD.n476 VSS 0.09853f
C1313 VDD.t70 VSS 0.15427f
C1314 VDD.t43 VSS 0.20399f
C1315 VDD.t194 VSS 0.20399f
C1316 VDD.t192 VSS 0.15172f
C1317 VDD.n477 VSS 0.09853f
C1318 VDD.t112 VSS 0.15427f
C1319 VDD.t47 VSS 0.20399f
C1320 VDD.t4 VSS 0.20399f
C1321 VDD.t0 VSS 0.15172f
C1322 VDD.t12 VSS 0.20399f
C1323 VDD.t88 VSS 0.20399f
C1324 VDD.t24 VSS 0.15427f
C1325 VDD.n478 VSS 0.09853f
C1326 VDD.n479 VSS 0.03503f
C1327 VDD.n480 VSS 0.03503f
C1328 VDD.n481 VSS 0.09853f
C1329 VDD.t6 VSS 0.15427f
C1330 VDD.t82 VSS 0.20399f
C1331 VDD.t183 VSS 0.20399f
C1332 VDD.t211 VSS 0.15172f
C1333 VDD.n482 VSS 0.09853f
C1334 VDD.t209 VSS 0.15427f
C1335 VDD.t126 VSS 0.20399f
C1336 VDD.t53 VSS 0.20399f
C1337 VDD.t8 VSS 0.2187f
C1338 VDD.n483 VSS 0.26597f
C1339 VDD.n484 VSS 0.02712f
C1340 VDD.n485 VSS 0.05072f
C1341 VDD.n486 VSS 0.05086f
C1342 VDD.n487 VSS 0.13586f
C1343 VDD.n488 VSS 0.0866f
C1344 VDD.n489 VSS 0.05086f
C1345 VDD.n490 VSS 0.05086f
C1346 VDD.n491 VSS 0.05086f
C1347 VDD.n492 VSS 0.05086f
C1348 VDD.n493 VSS 0.05086f
C1349 VDD.n494 VSS 0.0866f
C1350 VDD.n495 VSS 0.0866f
C1351 VDD.n496 VSS 0.05086f
C1352 VDD.n497 VSS 0.05086f
C1353 VDD.n498 VSS 0.03516f
C1354 VDD.n499 VSS 0.01305f
C1355 VDD.n500 VSS 0.43529f
C1356 VDD.n501 VSS 0.46175f
C1357 VDD.n502 VSS 0.10477f
C1358 VDD.n503 VSS 0.05198f
C1359 VDD.n504 VSS 1.35328f
C1360 VDD.n505 VSS 1.35328f
C1361 VDD.n506 VSS 1.15825f
C1362 VDD.n507 VSS 0.04465f
C1363 VDD.n508 VSS 0.05198f
C1364 VDD.n509 VSS 0.25432f
C1365 VDD.t118 VSS 0.67837f
C1366 VDD.n510 VSS 1.29053f
C1367 VDD.n511 VSS 1.35328f
C1368 VDD.n512 VSS 0.04465f
C1369 VDD.n513 VSS 0.05198f
C1370 VDD.n514 VSS 0.15408f
C1371 VDD.n515 VSS 0.14205f
C1372 VDD.n516 VSS 0.05198f
C1373 VDD.n517 VSS 1.35328f
C1374 VDD.n518 VSS 1.35328f
C1375 VDD.n519 VSS 1.35328f
C1376 VDD.n520 VSS 0.04465f
C1377 VDD.n521 VSS 0.05198f
C1378 VDD.n522 VSS 0.09394f
C1379 VDD.n523 VSS 0.11349f
C1380 VDD.n524 VSS 0.05198f
C1381 VDD.n525 VSS 0.04465f
C1382 VDD.n526 VSS 0.04465f
C1383 VDD.n527 VSS 0.68339f
C1384 VDD.t80 VSS 0.67837f
C1385 VDD.n528 VSS 1.3448f
C1386 VDD.n529 VSS 1.35328f
C1387 VDD.n530 VSS 0.04465f
C1388 VDD.n531 VSS 0.04465f
C1389 VDD.n532 VSS 0.05198f
C1390 VDD.n533 VSS 0.83263f
C1391 VDD.t196 VSS 0.67837f
C1392 VDD.n534 VSS 1.19556f
C1393 VDD.n535 VSS 1.35328f
C1394 VDD.n536 VSS 0.04465f
C1395 VDD.n537 VSS 0.04718f
C1396 VDD.n538 VSS 0.29988f
C1397 VDD.n539 VSS 0.10344f
C1398 VDD.t146 VSS 0.16419f
C1399 VDD.t208 VSS 0.1608f
C1400 VDD.n540 VSS 0.16036f
C1401 VDD.n541 VSS 0.23899f
C1402 VDD_VCO.n0 VSS 0.08358f
C1403 VDD_VCO.t2 VSS 0.01207f
C1404 VDD_VCO.t26 VSS 0.01207f
C1405 VDD_VCO.n1 VSS 0.04864f
C1406 VDD_VCO.n2 VSS 0.02285f
C1407 VDD_VCO.t49 VSS 0.01207f
C1408 VDD_VCO.t59 VSS 0.01207f
C1409 VDD_VCO.n3 VSS 0.04864f
C1410 VDD_VCO.n4 VSS 0.08544f
C1411 VDD_VCO.t33 VSS 0.01207f
C1412 VDD_VCO.t16 VSS 0.01207f
C1413 VDD_VCO.n5 VSS 0.04864f
C1414 VDD_VCO.n6 VSS 0.02285f
C1415 VDD_VCO.t1 VSS 0.01207f
C1416 VDD_VCO.t0 VSS 0.01207f
C1417 VDD_VCO.n7 VSS 0.04864f
C1418 VDD_VCO.n8 VSS 0.08544f
C1419 VDD_VCO.t28 VSS 0.01207f
C1420 VDD_VCO.t37 VSS 0.01207f
C1421 VDD_VCO.n9 VSS 0.04864f
C1422 VDD_VCO.n10 VSS 0.02285f
C1423 VDD_VCO.t22 VSS 0.01207f
C1424 VDD_VCO.t21 VSS 0.01207f
C1425 VDD_VCO.n11 VSS 0.04864f
C1426 VDD_VCO.n12 VSS 0.08544f
C1427 VDD_VCO.t32 VSS 0.01207f
C1428 VDD_VCO.t55 VSS 0.01207f
C1429 VDD_VCO.n13 VSS 0.04864f
C1430 VDD_VCO.n14 VSS 0.02285f
C1431 VDD_VCO.t54 VSS 0.01207f
C1432 VDD_VCO.t20 VSS 0.01207f
C1433 VDD_VCO.n15 VSS 0.04864f
C1434 VDD_VCO.n16 VSS 0.08544f
C1435 VDD_VCO.t6 VSS 0.01207f
C1436 VDD_VCO.t31 VSS 0.01207f
C1437 VDD_VCO.n17 VSS 0.04864f
C1438 VDD_VCO.n18 VSS 0.02285f
C1439 VDD_VCO.t40 VSS 0.01207f
C1440 VDD_VCO.t18 VSS 0.01207f
C1441 VDD_VCO.n19 VSS 0.04864f
C1442 VDD_VCO.n20 VSS 0.23864f
C1443 VDD_VCO.t39 VSS 0.01207f
C1444 VDD_VCO.t38 VSS 0.01207f
C1445 VDD_VCO.n21 VSS 0.04864f
C1446 VDD_VCO.t7 VSS 0.01207f
C1447 VDD_VCO.t50 VSS 0.01207f
C1448 VDD_VCO.n22 VSS 0.04976f
C1449 VDD_VCO.n23 VSS 0.03656f
C1450 VDD_VCO.n24 VSS 0.02285f
C1451 VDD_VCO.t51 VSS 0.01207f
C1452 VDD_VCO.t13 VSS 0.01207f
C1453 VDD_VCO.n25 VSS 0.04864f
C1454 VDD_VCO.n26 VSS 0.02285f
C1455 VDD_VCO.t12 VSS 0.01207f
C1456 VDD_VCO.t8 VSS 0.01207f
C1457 VDD_VCO.n27 VSS 0.04864f
C1458 VDD_VCO.n28 VSS 0.02285f
C1459 VDD_VCO.n29 VSS 0.08544f
C1460 VDD_VCO.n30 VSS 0.08544f
C1461 VDD_VCO.n31 VSS 0.08544f
C1462 VDD_VCO.n32 VSS 0.02285f
C1463 VDD_VCO.t48 VSS 0.01207f
C1464 VDD_VCO.t15 VSS 0.01207f
C1465 VDD_VCO.n33 VSS 0.04864f
C1466 VDD_VCO.n34 VSS 0.02285f
C1467 VDD_VCO.t47 VSS 0.01207f
C1468 VDD_VCO.t46 VSS 0.01207f
C1469 VDD_VCO.n35 VSS 0.04864f
C1470 VDD_VCO.n36 VSS 0.02285f
C1471 VDD_VCO.n37 VSS 0.08544f
C1472 VDD_VCO.n38 VSS 0.08544f
C1473 VDD_VCO.n39 VSS 0.08544f
C1474 VDD_VCO.n40 VSS 0.02285f
C1475 VDD_VCO.t10 VSS 0.01207f
C1476 VDD_VCO.t9 VSS 0.01207f
C1477 VDD_VCO.n41 VSS 0.04864f
C1478 VDD_VCO.n42 VSS 0.02285f
C1479 VDD_VCO.t43 VSS 0.01207f
C1480 VDD_VCO.t62 VSS 0.01207f
C1481 VDD_VCO.n43 VSS 0.04864f
C1482 VDD_VCO.n44 VSS 0.02285f
C1483 VDD_VCO.n45 VSS 0.08544f
C1484 VDD_VCO.n46 VSS 0.08544f
C1485 VDD_VCO.n47 VSS 0.08544f
C1486 VDD_VCO.n48 VSS 0.02285f
C1487 VDD_VCO.t19 VSS 0.01207f
C1488 VDD_VCO.t14 VSS 0.01207f
C1489 VDD_VCO.n49 VSS 0.04864f
C1490 VDD_VCO.n50 VSS 0.02285f
C1491 VDD_VCO.t53 VSS 0.01207f
C1492 VDD_VCO.t52 VSS 0.01207f
C1493 VDD_VCO.n51 VSS 0.04864f
C1494 VDD_VCO.n52 VSS 0.02285f
C1495 VDD_VCO.n53 VSS 0.08544f
C1496 VDD_VCO.n54 VSS 0.08544f
C1497 VDD_VCO.n55 VSS 0.08544f
C1498 VDD_VCO.n56 VSS 0.02285f
C1499 VDD_VCO.t11 VSS 0.01207f
C1500 VDD_VCO.t27 VSS 0.01207f
C1501 VDD_VCO.n57 VSS 0.04864f
C1502 VDD_VCO.n58 VSS 0.02285f
C1503 VDD_VCO.t5 VSS 0.01207f
C1504 VDD_VCO.t4 VSS 0.01207f
C1505 VDD_VCO.n59 VSS 0.04864f
C1506 VDD_VCO.n60 VSS 0.02285f
C1507 VDD_VCO.n61 VSS 0.08544f
C1508 VDD_VCO.n62 VSS 0.08544f
C1509 VDD_VCO.n63 VSS 0.08544f
C1510 VDD_VCO.n64 VSS 0.02285f
C1511 VDD_VCO.t58 VSS 0.01207f
C1512 VDD_VCO.t34 VSS 0.01207f
C1513 VDD_VCO.n65 VSS 0.04864f
C1514 VDD_VCO.t25 VSS 0.17426f
C1515 VDD_VCO.t65 VSS 2.06412f
C1516 VDD_VCO.t66 VSS 1.91517f
C1517 VDD_VCO.n66 VSS 1.68923f
C1518 VDD_VCO.t67 VSS 1.91517f
C1519 VDD_VCO.n67 VSS 0.93478f
C1520 VDD_VCO.t68 VSS 1.91517f
C1521 VDD_VCO.n68 VSS 0.93478f
C1522 VDD_VCO.t69 VSS 1.91517f
C1523 VDD_VCO.n69 VSS 0.93478f
C1524 VDD_VCO.t70 VSS 1.91517f
C1525 VDD_VCO.n70 VSS 0.93478f
C1526 VDD_VCO.t71 VSS 1.91517f
C1527 VDD_VCO.n71 VSS 0.93478f
C1528 VDD_VCO.t72 VSS 1.91517f
C1529 VDD_VCO.n72 VSS 0.93478f
C1530 VDD_VCO.t73 VSS 1.91517f
C1531 VDD_VCO.n73 VSS 0.91737f
C1532 VDD_VCO.t82 VSS 2.06412f
C1533 VDD_VCO.t81 VSS 1.91517f
C1534 VDD_VCO.n74 VSS 1.68923f
C1535 VDD_VCO.t80 VSS 1.91517f
C1536 VDD_VCO.n75 VSS 0.93478f
C1537 VDD_VCO.t79 VSS 1.91517f
C1538 VDD_VCO.n76 VSS 0.93478f
C1539 VDD_VCO.t78 VSS 1.91517f
C1540 VDD_VCO.n77 VSS 0.93478f
C1541 VDD_VCO.t77 VSS 1.91517f
C1542 VDD_VCO.n78 VSS 0.93478f
C1543 VDD_VCO.t76 VSS 1.91517f
C1544 VDD_VCO.n79 VSS 0.93478f
C1545 VDD_VCO.t75 VSS 1.91517f
C1546 VDD_VCO.n80 VSS 0.93478f
C1547 VDD_VCO.t74 VSS 1.91517f
C1548 VDD_VCO.n81 VSS 0.91895f
C1549 VDD_VCO.n82 VSS 0.05739f
C1550 VDD_VCO.n83 VSS 0.93119f
C1551 VDD_VCO.n84 VSS 0.40056f
C1552 VDD_VCO.n85 VSS 0.01913f
C1553 VDD_VCO.t17 VSS 0.01207f
C1554 VDD_VCO.t3 VSS 0.01207f
C1555 VDD_VCO.n86 VSS 0.04864f
C1556 VDD_VCO.n87 VSS 0.01727f
C1557 VDD_VCO.n88 VSS 0.35957f
C1558 VDD_VCO.t24 VSS 0.031f
C1559 VDD_VCO.t45 VSS 0.0322f
C1560 VDD_VCO.t23 VSS 0.18362f
C1561 VDD_VCO.t44 VSS 0.18362f
C1562 VDD_VCO.n89 VSS 0.1435f
C1563 VDD_VCO.n90 VSS 0.03747f
C1564 VDD_VCO.n91 VSS 0.04648f
C1565 VDD_VCO.t61 VSS 0.03094f
C1566 VDD_VCO.t30 VSS 0.03112f
C1567 VDD_VCO.n92 VSS 0.01345f
C1568 VDD_VCO.n93 VSS 0.08358f
C1569 VDD_VCO.t60 VSS 0.15899f
C1570 VDD_VCO.t29 VSS 0.15899f
C1571 VDD_VCO.n94 VSS 0.11493f
C1572 VDD_VCO.t63 VSS 0.15899f
C1573 VDD_VCO.t56 VSS 0.15899f
C1574 VDD_VCO.n95 VSS 0.11212f
C1575 VDD_VCO.n96 VSS 0.03588f
C1576 VDD_VCO.n97 VSS 0.04225f
C1577 VDD_VCO.t64 VSS 0.03109f
C1578 VDD_VCO.t57 VSS 0.03095f
C1579 VDD_VCO.n98 VSS 0.01347f
C1580 VDD_VCO.n99 VSS 0.0209f
C1581 VDD_VCO.t42 VSS 0.03221f
C1582 VDD_VCO.t41 VSS 0.18362f
C1583 VDD_VCO.t35 VSS 0.18362f
C1584 VDD_VCO.n100 VSS 0.1435f
C1585 VDD_VCO.n101 VSS 0.04016f
C1586 VDD_VCO.t36 VSS 0.03093f
C1587 VDD_VCO.n102 VSS 0.06254f
C1588 VDD_VCO.n103 VSS 0.04622f
C1589 CORE_CLK.t11 VSS 0.07658f
C1590 CORE_CLK.t7 VSS 0.06389f
C1591 CORE_CLK.n0 VSS 0.73259f
C1592 CORE_CLK.t5 VSS 0.06684f
C1593 CORE_CLK.t9 VSS 0.07004f
C1594 CORE_CLK.n1 VSS 0.79931f
C1595 CORE_CLK.t10 VSS 0.05668f
C1596 CORE_CLK.t6 VSS 0.06684f
C1597 CORE_CLK.t12 VSS 0.07658f
C1598 CORE_CLK.t8 VSS 0.06389f
C1599 CORE_CLK.n2 VSS 0.83433f
C1600 CORE_CLK.n3 VSS 0.42621f
C1601 CORE_CLK.n4 VSS 0.57683f
C1602 CORE_CLK.n5 VSS 0.3218f
C1603 CORE_CLK.t4 VSS 0.05359f
C1604 CORE_CLK.n6 VSS 0.34975f
C1605 CORE_CLK.t3 VSS 0.03003f
C1606 CORE_CLK.n7 VSS 0.24053f
C1607 CORE_CLK.t2 VSS 0.04459f
C1608 CORE_CLK.n8 VSS 0.36945f
C1609 CORE_CLK.t0 VSS 0.58991f
C1610 CORE_CLK.t1 VSS 0.21225f
C1611 CORE_CLK.n9 VSS 0.65696f
C1612 CP_IBIAS.t0 VSS 0.61168f
C1613 TAIL_BIAS.t0 VSS 0.05118f
C1614 TAIL_BIAS.t3 VSS 0.97092f
C1615 TAIL_BIAS.t4 VSS 0.88811f
C1616 TAIL_BIAS.n0 VSS 1.23843f
C1617 TAIL_BIAS.t5 VSS 0.97061f
C1618 TAIL_BIAS.n1 VSS 0.60029f
C1619 TAIL_BIAS.n2 VSS 0.09962f
C1620 TAIL_BIAS.t2 VSS 0.01496f
C1621 TAIL_BIAS.n3 VSS 0.05271f
C1622 TAIL_BIAS.t1 VSS 0.07637f
C1623 TAIL_BIAS.n4 VSS 0.04436f
C1624 TAIL_BIAS.t6 VSS 0.03461f
C1625 PRESCALED.n0 VSS 0.05818f
C1626 PRESCALED.t0 VSS 0.01659f
C1627 PRESCALED.n1 VSS 0.09247f
C1628 PRESCALED.n2 VSS 0.1205f
C1629 MC.t0 VSS 0.02688f
C1630 O1P.t3 VSS 0.63217f
C1631 O1P.t2 VSS 0.30136f
C1632 O1P.n0 VSS 0.9383f
C1633 O1P.t0 VSS 0.08568f
C1634 O1P.t6 VSS 0.04526f
C1635 O1P.t5 VSS 0.21281f
C1636 O1P.t4 VSS 0.11342f
C1637 O1P.n1 VSS 0.99616f
C1638 O1P.t8 VSS 0.11704f
C1639 O1P.t7 VSS 0.33451f
C1640 O1P.n2 VSS 1.28357f
C1641 O1P.n3 VSS 0.38824f
C1642 O1P.n4 VSS 0.17795f
C1643 O1P.n5 VSS 0.21416f
C1644 O1P.n6 VSS 0.10749f
C1645 O1P.t1 VSS 0.16133f
C1646 VTUNE.t7 VSS 0.05125f
C1647 VTUNE.t6 VSS 0.07185f
C1648 VTUNE.t5 VSS 0.07386f
C1649 VTUNE.t4 VSS 0.07185f
C1650 VTUNE.n0 VSS 0.18052f
C1651 VTUNE.t3 VSS 0.07185f
C1652 VTUNE.n1 VSS 0.10964f
C1653 VTUNE.t0 VSS 0.07185f
C1654 VTUNE.n2 VSS 0.265f
C1655 VTUNE.t2 VSS 0.07945f
C1656 VTUNE.t1 VSS 0.07185f
C1657 VTUNE.n3 VSS 0.64651f
C1658 VTUNE.n4 VSS 0.4415f
C1659 O1N.t5 VSS 0.04796f
C1660 O1N.t2 VSS 0.15105f
C1661 O1N.t3 VSS 0.27387f
C1662 O1N.t6 VSS 0.16157f
C1663 O1N.t4 VSS 0.21377f
C1664 O1N.n0 VSS 1.70613f
C1665 O1N.n1 VSS 0.2564f
C1666 O1N.n2 VSS 0.19452f
C1667 O1N.n3 VSS 0.27001f
C1668 O1N.t1 VSS 0.38052f
C1669 O1N.t7 VSS 0.29257f
C1670 O1N.n4 VSS 0.80735f
C1671 O1N.t8 VSS 0.1738f
C1672 O1N.n5 VSS 1.05088f
C1673 O1N.t0 VSS 0.07352f
C1674 O1N.n6 VSS 0.10721f
C1675 RF_DRV1.t3 VSS 0.08392f
C1676 RF_DRV1.t2 VSS 0.04315f
C1677 RF_DRV1.n0 VSS 0.13107f
C1678 RF_DRV1.t1 VSS 0.10963f
C1679 RF_DRV1.n1 VSS 0.27635f
C1680 RF_DRV1.t4 VSS 0.02238f
C1681 RF_DRV1.t0 VSS 0.18315f
C1682 RF_DRV1.t5 VSS 0.0391f
C1683 RF_DRV1.n2 VSS 0.31071f
C1684 RF_DRV1.n3 VSS 0.17559f
C1685 MIM_TOP.t0 VSS 0.01719f
C1686 MIM_TOP.t3 VSS 0.01616f
C1687 MIM_TOP.n0 VSS 0.05131f
C1688 MIM_TOP.t1 VSS 1.91588f
C1689 MIM_TOP.n1 VSS 0.08599f
C1690 O3P.t4 VSS 0.0596f
C1691 O3P.t2 VSS 0.11535f
C1692 O3P.t3 VSS 0.05768f
C1693 O3P.t5 VSS 0.03663f
C1694 O3P.n0 VSS 0.25554f
C1695 O3P.n1 VSS 0.13454f
C1696 O3P.t1 VSS 0.20823f
C1697 O3P.n2 VSS 0.31283f
C1698 O3P.t0 VSS 0.20852f
C1699 O3P.n3 VSS 0.17376f
C1700 O3P.t6 VSS 0.11717f
C1701 O3P.n4 VSS 0.9335f
C1702 O4N.t4 VSS 0.15683f
C1703 O4N.t6 VSS 0.10029f
C1704 O4N.n0 VSS 1.34644f
C1705 O4N.t2 VSS 0.2547f
C1706 O4N.n1 VSS 0.34509f
C1707 O4N.t1 VSS 0.07242f
C1708 O4N.t0 VSS 0.19811f
C1709 O4N.t5 VSS 0.03833f
C1710 O4N.n2 VSS 0.37964f
C1711 O4N.n3 VSS 0.17795f
C1712 O4N.n4 VSS 0.09085f
C1713 O4N.t3 VSS 0.13635f
C1714 O2P.t6 VSS 0.09348f
C1715 O2P.t5 VSS 0.17899f
C1716 O2P.t1 VSS 0.18094f
C1717 O2P.t3 VSS 0.09048f
C1718 O2P.t4 VSS 0.05745f
C1719 O2P.n0 VSS 0.40084f
C1720 O2P.n1 VSS 0.21076f
C1721 O2P.t0 VSS 0.283f
C1722 O2P.n2 VSS 0.43655f
C1723 O2P.t2 VSS 0.32677f
C1724 O2P.n3 VSS 0.2924f
C1725 O2P.n4 VSS 0.99208f
C1726 O3N.t1 VSS 0.14362f
C1727 O3N.t2 VSS 0.07628f
C1728 O3N.t6 VSS 0.04673f
C1729 O3N.n0 VSS 0.30939f
C1730 O3N.t0 VSS 0.23536f
C1731 O3N.t3 VSS 0.26827f
C1732 O3N.n1 VSS 0.51223f
C1733 O3N.t4 VSS 0.18233f
C1734 O3N.t5 VSS 0.14229f
C1735 O3N.n2 VSS 1.08644f
C1736 O3N.n3 VSS 0.16717f
C1737 O3N.n4 VSS 0.084f
C1738 O4P.t6 VSS 0.10537f
C1739 O4P.t5 VSS 0.16961f
C1740 O4P.n0 VSS 0.84803f
C1741 O4P.t4 VSS 0.04803f
C1742 O4P.n1 VSS 0.20584f
C1743 O4P.t0 VSS 0.1815f
C1744 O4P.t2 VSS 0.37616f
C1745 O4P.t1 VSS 0.27804f
C1746 O4P.n2 VSS 0.75628f
C1747 O4P.n3 VSS 0.2072f
C1748 O4P.n4 VSS 0.14788f
C1749 O4P.t3 VSS 0.08848f
C1750 O2N.t2 VSS 0.11501f
C1751 O2N.t1 VSS 0.06108f
C1752 O2N.t6 VSS 0.0754f
C1753 O2N.t4 VSS 0.17212f
C1754 O2N.n0 VSS 0.98356f
C1755 O2N.t5 VSS 0.03227f
C1756 O2N.n1 VSS 0.12649f
C1757 O2N.n2 VSS 0.15268f
C1758 O2N.t0 VSS 0.20206f
C1759 O2N.t3 VSS 0.24951f
C1760 O2N.n3 VSS 0.54184f
C1761 O2N.n4 VSS 0.05557f
C1762 D1.t15 VSS 0.07838f
C1763 D1.t16 VSS 0.07818f
C1764 D1.n0 VSS 0.13336f
C1765 D1.t17 VSS 0.07818f
C1766 D1.n1 VSS 0.07134f
C1767 D1.t18 VSS 0.07818f
C1768 D1.n2 VSS 0.07134f
C1769 D1.t19 VSS 0.07818f
C1770 D1.n3 VSS 0.07134f
C1771 D1.t20 VSS 0.07818f
C1772 D1.n4 VSS 0.07134f
C1773 D1.t21 VSS 0.07818f
C1774 D1.n5 VSS 0.07134f
C1775 D1.t22 VSS 0.07818f
C1776 D1.n6 VSS 0.07134f
C1777 D1.t23 VSS 0.07818f
C1778 D1.n7 VSS 0.07134f
C1779 D1.t24 VSS 0.07818f
C1780 D1.n8 VSS 0.07134f
C1781 D1.t25 VSS 0.07818f
C1782 D1.n9 VSS 0.07134f
C1783 D1.t26 VSS 0.07818f
C1784 D1.n10 VSS 0.07134f
C1785 D1.t27 VSS 0.07818f
C1786 D1.n11 VSS 0.07134f
C1787 D1.t28 VSS 0.07818f
C1788 D1.n12 VSS 0.07134f
C1789 D1.t29 VSS 0.07818f
C1790 D1.n13 VSS 0.06721f
C1791 D1.t30 VSS 0.07818f
C1792 D1.t11 VSS 0.04248f
C1793 D1.t9 VSS 0.04248f
C1794 D1.n14 VSS 0.16316f
C1795 D1.t7 VSS 0.04248f
C1796 D1.t5 VSS 0.04248f
C1797 D1.n15 VSS 0.15886f
C1798 D1.n16 VSS 0.13145f
C1799 D1.t3 VSS 0.04248f
C1800 D1.t1 VSS 0.04248f
C1801 D1.n17 VSS 0.15886f
C1802 D1.n18 VSS 0.07971f
C1803 D1.t13 VSS 0.24648f
C1804 D1.n19 VSS 0.16976f
C1805 D1.t0 VSS 0.07427f
C1806 D1.t10 VSS 0.07427f
C1807 D1.n20 VSS 0.31737f
C1808 D1.t8 VSS 0.07427f
C1809 D1.t6 VSS 0.07427f
C1810 D1.n21 VSS 0.31254f
C1811 D1.n22 VSS 0.13654f
C1812 D1.t4 VSS 0.07427f
C1813 D1.t2 VSS 0.07427f
C1814 D1.n23 VSS 0.31254f
C1815 D1.n24 VSS 0.08028f
C1816 D1.t14 VSS 0.07427f
C1817 D1.t12 VSS 0.07427f
C1818 D1.n25 VSS 0.31254f
C1819 D1.n26 VSS 0.12778f
C1820 D1.n27 VSS 0.22573f
C1821 PA_DRAIN.t15 VSS 0.01202f
C1822 PA_DRAIN.t14 VSS 0.01202f
C1823 PA_DRAIN.t13 VSS 0.01202f
C1824 PA_DRAIN.t12 VSS 0.01202f
C1825 PA_DRAIN.n2 VSS 0.15019f
C1826 PA_DRAIN.t11 VSS 0.01202f
C1827 PA_DRAIN.t10 VSS 0.01202f
C1828 PA_DRAIN.n4 VSS 0.08858f
C1829 PA_DRAIN.t9 VSS 0.01202f
C1830 PA_DRAIN.t8 VSS 0.01202f
C1831 PA_DRAIN.n6 VSS 0.08858f
C1832 PA_DRAIN.t5 VSS 0.01202f
C1833 PA_DRAIN.t4 VSS 0.01202f
C1834 PA_DRAIN.n8 VSS 0.08858f
C1835 PA_DRAIN.t3 VSS 0.01202f
C1836 PA_DRAIN.t2 VSS 0.01202f
C1837 PA_DRAIN.n10 VSS 0.08858f
C1838 PA_DRAIN.t1 VSS 0.01202f
C1839 PA_DRAIN.t0 VSS 0.01202f
C1840 PA_DRAIN.n12 VSS 0.08858f
C1841 PA_DRAIN.t7 VSS 0.01202f
C1842 PA_DRAIN.t6 VSS 0.01202f
C1843 PA_DRAIN.n14 VSS 0.10856f
C1844 VCTRL.t0 VSS 2.24612f
.ends
