* NGSPICE file created from RF_CHAIN_PA_FLAT.ext - technology: gf180mcuE

.subckt RF_CHAIN_PA_FLAT PA_DRAIN RF_DRV1 D1 VSS VDD
X0 a_n810_5600.t1 a_214_200.t0 VSS.t1 ppolyf_u_1k r_width=1u r_length=5.37u
X1 RF_DRV1.t0 a_392_3000.t1 VSS.t1 ppolyf_u_1k r_width=1u r_length=5.37u
X2 D1.t3 a_8006_200.t20 VDD.t4 VDD.t0 pfet_03v3 ad=1.3p pd=5.52u as=1.3p ps=5.52u w=5u l=0.28u
X3 a_6500_3520.t0 a_7112_3000.t1 VSS.t71 ppolyf_u_1k r_width=1u r_length=2.42u
X4 VDD.t14 a_8006_200.t21 D1.t8 VDD.t0 pfet_03v3 ad=1.3p pd=5.52u as=1.3p ps=5.52u w=5u l=0.28u
X5 a_214_200.t3 RF_DRV1.t1 VSS.t73 VSS.t72 nfet_03v3 ad=0.61p pd=3.22u as=0.61p ps=3.22u w=1u l=0.28u
X6 VSS.t3 a_6614_200.t10 a_8006_200.t0 VSS.t2 nfet_03v3 ad=0.78p pd=3.52u as=0.78p ps=3.52u w=3u l=0.28u
X7 VSS.t44 D1.t21 PA_DRAIN.t13 VSS.t43 nfet_03v3 ad=0.8125p pd=3.645u as=0.8125p ps=3.645u w=3.125u l=0.28u
X8 PA_DRAIN.t9 D1.t18 VSS.t50 VSS.t49 nfet_03v3 ad=0.8125p pd=3.645u as=0.8125p ps=3.645u w=3.125u l=0.28u
X9 a_n810_5600.t0 a_392_5080.t1 VSS.t1 ppolyf_u_1k r_width=1u r_length=5.37u
X10 a_214_200.t2 RF_DRV1.t2 VDD.t26 VDD.t25 pfet_03v3 ad=1.3p pd=5.3u as=1.3p ps=5.3u w=2u l=0.28u
X11 PA_DRAIN.t11 D1.t28 VSS.t30 VSS.t29 nfet_03v3 ad=0.8125p pd=3.645u as=0.8125p ps=3.645u w=3.125u l=0.28u
X12 VSS.t36 D1.t25 PA_DRAIN.t6 VSS.t35 nfet_03v3 ad=0.8125p pd=3.645u as=0.8125p ps=3.645u w=3.125u l=0.28u
X13 a_1040_4560.t1 a_2120_200.t2 VSS.t23 ppolyf_u_1k r_width=1u r_length=5.65u
X14 VSS.t68 a_5514_200.t7 a_6614_200.t6 VSS.t67 nfet_03v3 ad=0.6071p pd=2.855u as=0.6071p ps=2.855u w=2.335u l=0.28u
X15 a_2946_3520.t0 a_4156_200.t0 VSS.t0 ppolyf_u_1k r_width=1u r_length=6.3u
X16 a_8006_200.t6 a_6614_200.t16 VDD.t16 VDD.t9 pfet_03v3 ad=1.248p pd=5.32u as=3.12p ps=10.9u w=4.8u l=0.28u
X17 D1.t11 a_8006_200.t16 VSS.t60 VSS.t59 nfet_03v3 ad=0.7436p pd=3.38u as=1.7446p ps=6.94u w=2.86u l=0.28u
X18 a_5514_200.t5 a_7112_3000.t0 VSS.t71 ppolyf_u_1k r_width=1u r_length=2.42u
X19 a_6614_200.t1 a_5514_200.t11 VDD.t15 VDD.t5 pfet_03v3 ad=1.2129p pd=5.185u as=3.03225p ps=10.63u w=4.665u l=0.28u
X20 a_8006_200.t8 a_6614_200.t14 VDD.t17 VDD.t9 pfet_03v3 ad=1.248p pd=5.32u as=1.248p ps=5.32u w=4.8u l=0.28u
X21 a_8006_200.t3 a_6614_200.t9 VSS.t18 VSS.t17 nfet_03v3 ad=0.78p pd=3.52u as=0.78p ps=3.52u w=3u l=0.28u
X22 VSS.t14 a_8006_200.t13 D1.t5 VSS.t13 nfet_03v3 ad=0.7436p pd=3.38u as=0.7436p ps=3.38u w=2.86u l=0.28u
X23 a_1040_4560.t0 a_2298_4040.t0 VSS.t23 ppolyf_u_1k r_width=1u r_length=5.65u
X24 VDD.t13 a_4156_200.t6 a_5514_200.t2 VDD.t12 pfet_03v3 ad=2.6p pd=9.3u as=1.04p ps=4.52u w=4u l=0.28u
X25 VDD.t18 a_6614_200.t15 a_8006_200.t9 VDD.t9 pfet_03v3 ad=1.248p pd=5.32u as=1.248p ps=5.32u w=4.8u l=0.28u
X26 a_2120_200.t3 a_214_200.t4 VSS.t75 VSS.t74 nfet_03v3 ad=0.976p pd=4.42u as=0.976p ps=4.42u w=1.6u l=0.28u
X27 VSS.t52 D1.t17 PA_DRAIN.t7 VSS.t51 nfet_03v3 ad=0.8125p pd=3.645u as=0.8125p ps=3.645u w=3.125u l=0.28u
X28 a_4156_200.t2 a_2120_200.t4 VSS.t70 VSS.t69 nfet_03v3 ad=1.525p pd=6.22u as=1.525p ps=6.22u w=2.5u l=0.28u
X29 a_5514_200.t1 a_4156_200.t5 VSS.t9 VSS.t8 nfet_03v3 ad=0.52p pd=2.52u as=1.22p ps=5.22u w=2u l=0.28u
X30 PA_DRAIN.t3 D1.t24 VSS.t38 VSS.t37 nfet_03v3 ad=0.8125p pd=3.645u as=0.8125p ps=3.645u w=3.125u l=0.28u
X31 a_2946_3520.t1 a_4334_3000.t1 VSS.t0 ppolyf_u_1k r_width=1u r_length=6.3u
X32 a_6614_200.t5 a_5514_200.t6 VSS.t66 VSS.t65 nfet_03v3 ad=1.42435p pd=5.89u as=0.6071p ps=2.855u w=2.335u l=0.28u
X33 D1.t1 a_8006_200.t22 VDD.t2 VDD.t0 pfet_03v3 ad=1.3p pd=5.52u as=1.3p ps=5.52u w=5u l=0.28u
X34 D1.t4 a_8006_200.t12 VSS.t12 VSS.t11 nfet_03v3 ad=0.7436p pd=3.38u as=0.7436p ps=3.38u w=2.86u l=0.28u
X35 a_1040_3520.t1 a_2298_4040.t1 VSS.t23 ppolyf_u_1k r_width=1u r_length=5.65u
X36 VDD.t7 a_8006_200.t23 D1.t6 VDD.t0 pfet_03v3 ad=1.3p pd=5.52u as=1.3p ps=5.52u w=5u l=0.28u
X37 PA_DRAIN.t4 D1.t16 VSS.t54 VSS.t53 nfet_03v3 ad=0.8125p pd=3.645u as=0.8125p ps=3.645u w=3.125u l=0.28u
X38 a_2120_200.t1 a_4334_3000.t0 VSS.t0 ppolyf_u_1k r_width=1u r_length=6.3u
X39 VSS.t40 D1.t23 PA_DRAIN.t12 VSS.t39 nfet_03v3 ad=0.8125p pd=3.645u as=0.8125p ps=3.645u w=3.125u l=0.28u
X40 PA_DRAIN.t1 D1.t20 VSS.t46 VSS.t45 nfet_03v3 ad=0.8125p pd=3.645u as=0.8125p ps=3.645u w=3.125u l=0.28u
X41 a_n810_4560.t1 a_392_5080.t0 VSS.t1 ppolyf_u_1k r_width=1u r_length=5.37u
X42 a_2120_200.t0 a_214_200.t5 VDD.t24 VDD.t23 pfet_03v3 ad=2.08p pd=7.7u as=2.08p ps=7.7u w=3.2u l=0.28u
X43 PA_DRAIN.t5 D1.t30 VSS.t26 VSS.t25 nfet_03v3 ad=0.8125p pd=3.645u as=1.90625p ps=7.47u w=3.125u l=0.28u
X44 a_1040_3520.t0 a_2298_3000.t0 VSS.t23 ppolyf_u_1k r_width=1u r_length=5.65u
X45 a_5514_200.t3 a_4156_200.t7 VDD.t20 VDD.t12 pfet_03v3 ad=1.04p pd=4.52u as=2.6p ps=9.3u w=4u l=0.28u
X46 VSS.t64 a_8006_200.t11 D1.t14 VSS.t63 nfet_03v3 ad=0.7436p pd=3.38u as=0.7436p ps=3.38u w=2.86u l=0.28u
X47 VSS.t32 D1.t27 PA_DRAIN.t0 VSS.t31 nfet_03v3 ad=0.8125p pd=3.645u as=0.8125p ps=3.645u w=3.125u l=0.28u
X48 VDD.t21 a_8006_200.t17 D1.t12 VDD.t0 pfet_03v3 ad=3.25p pd=11.3u as=1.3p ps=5.52u w=5u l=0.28u
X49 a_n810_4560.t0 a_392_4040.t0 VSS.t1 ppolyf_u_1k r_width=1u r_length=5.37u
X50 a_4982_3520.t1 a_5514_200.t4 VSS.t10 ppolyf_u_1k r_width=1u r_length=3.71u
X51 D1.t2 a_8006_200.t18 VDD.t3 VDD.t0 pfet_03v3 ad=1.3p pd=5.52u as=1.3p ps=5.52u w=5u l=0.28u
X52 VSS.t22 a_8006_200.t15 D1.t10 VSS.t21 nfet_03v3 ad=0.7436p pd=3.38u as=0.7436p ps=3.38u w=2.86u l=0.28u
X53 VSS.t48 D1.t19 PA_DRAIN.t14 VSS.t47 nfet_03v3 ad=0.8125p pd=3.645u as=0.8125p ps=3.645u w=3.125u l=0.28u
X54 VSS.t16 a_6614_200.t8 a_8006_200.t2 VSS.t15 nfet_03v3 ad=1.83p pd=7.22u as=0.78p ps=3.52u w=3u l=0.28u
X55 a_4982_3520.t0 a_5852_3000.t0 VSS.t10 ppolyf_u_1k r_width=1u r_length=3.71u
X56 a_214_200.t1 a_2298_3000.t1 VSS.t23 ppolyf_u_1k r_width=1u r_length=5.65u
X57 D1.t0 a_8006_200.t24 VDD.t1 VDD.t0 pfet_03v3 ad=1.3p pd=5.52u as=3.25p ps=11.3u w=5u l=0.28u
X58 VSS.t28 D1.t29 PA_DRAIN.t2 VSS.t27 nfet_03v3 ad=0.8125p pd=3.645u as=0.8125p ps=3.645u w=3.125u l=0.28u
X59 PA_DRAIN.t8 D1.t26 VSS.t34 VSS.t33 nfet_03v3 ad=0.8125p pd=3.645u as=0.8125p ps=3.645u w=3.125u l=0.28u
X60 VSS.t7 a_4156_200.t4 a_5514_200.t0 VSS.t6 nfet_03v3 ad=1.22p pd=5.22u as=0.52p ps=2.52u w=2u l=0.28u
X61 a_n810_3520.t1 a_392_4040.t1 VSS.t1 ppolyf_u_1k r_width=1u r_length=5.37u
X62 a_6614_200.t3 a_5514_200.t8 VSS.t58 VSS.t57 nfet_03v3 ad=0.6071p pd=2.855u as=1.42435p ps=5.89u w=2.335u l=0.28u
X63 D1.t9 a_8006_200.t14 VSS.t20 VSS.t19 nfet_03v3 ad=0.7436p pd=3.38u as=0.7436p ps=3.38u w=2.86u l=0.28u
X64 VSS.t56 D1.t15 PA_DRAIN.t10 VSS.t55 nfet_03v3 ad=1.90625p pd=7.47u as=0.8125p ps=3.645u w=3.125u l=0.28u
X65 a_4156_200.t3 a_5852_3000.t1 VSS.t10 ppolyf_u_1k r_width=1u r_length=3.71u
X66 a_6614_200.t2 a_8006_200.t7 VSS.t24 ppolyf_u_1k r_width=1u r_length=4.68u
X67 a_n810_3520.t0 a_392_3000.t0 VSS.t1 ppolyf_u_1k r_width=1u r_length=5.37u
X68 a_6614_200.t4 a_5514_200.t9 VDD.t19 VDD.t5 pfet_03v3 ad=3.03225p pd=10.63u as=1.2129p ps=5.185u w=4.665u l=0.28u
X69 a_8006_200.t4 a_6614_200.t12 VDD.t10 VDD.t9 pfet_03v3 ad=3.12p pd=10.9u as=1.248p ps=5.32u w=4.8u l=0.28u
X70 a_8006_200.t1 a_6614_200.t11 VSS.t5 VSS.t4 nfet_03v3 ad=0.78p pd=3.52u as=1.83p ps=7.22u w=3u l=0.28u
X71 PA_DRAIN.t15 D1.t22 VSS.t42 VSS.t41 nfet_03v3 ad=0.8125p pd=3.645u as=0.8125p ps=3.645u w=3.125u l=0.28u
X72 a_4156_200.t1 a_2120_200.t5 VDD.t22 VDD.t0 pfet_03v3 ad=3.25p pd=11.3u as=3.25p ps=11.3u w=5u l=0.28u
X73 VDD.t6 a_5514_200.t10 a_6614_200.t0 VDD.t5 pfet_03v3 ad=1.2129p pd=5.185u as=1.2129p ps=5.185u w=4.665u l=0.28u
X74 VDD.t11 a_6614_200.t13 a_8006_200.t5 VDD.t9 pfet_03v3 ad=1.248p pd=5.32u as=1.248p ps=5.32u w=4.8u l=0.28u
X75 VDD.t8 a_8006_200.t19 D1.t7 VDD.t0 pfet_03v3 ad=1.3p pd=5.52u as=1.3p ps=5.52u w=5u l=0.28u
X76 a_6500_3520.t1 a_6614_200.t7 VSS.t71 ppolyf_u_1k r_width=1u r_length=2.42u
X77 D1.t13 a_8006_200.t10 VSS.t62 VSS.t61 nfet_03v3 ad=1.7446p pd=6.94u as=0.7436p ps=3.38u w=2.86u l=0.28u
R0 PA_DRAIN.n2 PA_DRAIN.n0 14.6339
R1 PA_DRAIN.n2 PA_DRAIN.n1 14.5539
R2 PA_DRAIN.n4 PA_DRAIN.n3 14.5539
R3 PA_DRAIN.n6 PA_DRAIN.n5 14.5539
R4 PA_DRAIN.n8 PA_DRAIN.n7 14.5539
R5 PA_DRAIN.n10 PA_DRAIN.n9 14.5539
R6 PA_DRAIN.n12 PA_DRAIN.n11 14.5539
R7 PA_DRAIN.n14 PA_DRAIN.n13 14.5539
R8 PA_DRAIN.n0 PA_DRAIN.t2 0.52466
R9 PA_DRAIN.n0 PA_DRAIN.t5 0.52466
R10 PA_DRAIN.n1 PA_DRAIN.t0 0.52466
R11 PA_DRAIN.n1 PA_DRAIN.t11 0.52466
R12 PA_DRAIN.n3 PA_DRAIN.t6 0.52466
R13 PA_DRAIN.n3 PA_DRAIN.t8 0.52466
R14 PA_DRAIN.n5 PA_DRAIN.t12 0.52466
R15 PA_DRAIN.n5 PA_DRAIN.t3 0.52466
R16 PA_DRAIN.n7 PA_DRAIN.t13 0.52466
R17 PA_DRAIN.n7 PA_DRAIN.t15 0.52466
R18 PA_DRAIN.n9 PA_DRAIN.t14 0.52466
R19 PA_DRAIN.n9 PA_DRAIN.t1 0.52466
R20 PA_DRAIN.n11 PA_DRAIN.t7 0.52466
R21 PA_DRAIN.n11 PA_DRAIN.t9 0.52466
R22 PA_DRAIN.n13 PA_DRAIN.t10 0.52466
R23 PA_DRAIN.n13 PA_DRAIN.t4 0.52466
R24 PA_DRAIN PA_DRAIN.n14 0.118
R25 PA_DRAIN.n14 PA_DRAIN.n12 0.0805
R26 PA_DRAIN.n12 PA_DRAIN.n10 0.0805
R27 PA_DRAIN.n10 PA_DRAIN.n8 0.0805
R28 PA_DRAIN.n8 PA_DRAIN.n6 0.0805
R29 PA_DRAIN.n6 PA_DRAIN.n4 0.0805
R30 PA_DRAIN.n4 PA_DRAIN.n2 0.0805
R31 D1.n14 D1.t15 60.4632
R32 D1 D1.t30 60.2737
R33 D1.n27 D1.t29 60.2737
R34 D1.n26 D1.t28 60.2737
R35 D1.n25 D1.t27 60.2737
R36 D1.n24 D1.t26 60.2737
R37 D1.n23 D1.t25 60.2737
R38 D1.n22 D1.t24 60.2737
R39 D1.n21 D1.t23 60.2737
R40 D1.n20 D1.t22 60.2737
R41 D1.n19 D1.t21 60.2737
R42 D1.n18 D1.t20 60.2737
R43 D1.n17 D1.t19 60.2737
R44 D1.n16 D1.t18 60.2737
R45 D1.n15 D1.t17 60.2737
R46 D1.n14 D1.t16 60.2737
R47 D1.n12 D1.t13 6.84767
R48 D1.n9 D1.n7 6.44227
R49 D1.n2 D1.n0 6.01347
R50 D1.n11 D1.n10 5.96655
R51 D1.n9 D1.n8 5.96655
R52 D1.n6 D1.n5 5.53775
R53 D1.n4 D1.n3 5.53775
R54 D1.n2 D1.n1 5.53775
R55 D1 D1.n13 5.12238
R56 D1.n13 D1.n12 1.68479
R57 D1.n13 D1.n6 1.37621
R58 D1.n10 D1.t14 0.573227
R59 D1.n10 D1.t4 0.573227
R60 D1.n8 D1.t5 0.573227
R61 D1.n8 D1.t9 0.573227
R62 D1.n7 D1.t10 0.573227
R63 D1.n7 D1.t11 0.573227
R64 D1.n12 D1.n11 0.521214
R65 D1.n4 D1.n2 0.476214
R66 D1.n6 D1.n4 0.476214
R67 D1.n11 D1.n9 0.476214
R68 D1.n5 D1.t12 0.3645
R69 D1.n5 D1.t2 0.3645
R70 D1.n3 D1.t7 0.3645
R71 D1.n3 D1.t3 0.3645
R72 D1.n1 D1.t8 0.3645
R73 D1.n1 D1.t1 0.3645
R74 D1.n0 D1.t6 0.3645
R75 D1.n0 D1.t0 0.3645
R76 D1.n15 D1.n14 0.189974
R77 D1.n16 D1.n15 0.189974
R78 D1.n17 D1.n16 0.189974
R79 D1.n18 D1.n17 0.189974
R80 D1.n19 D1.n18 0.189974
R81 D1.n20 D1.n19 0.189974
R82 D1.n21 D1.n20 0.189974
R83 D1.n22 D1.n21 0.189974
R84 D1.n23 D1.n22 0.189974
R85 D1.n24 D1.n23 0.189974
R86 D1.n25 D1.n24 0.189974
R87 D1.n26 D1.n25 0.189974
R88 D1.n27 D1.n26 0.189974
R89 D1 D1.n27 0.189974
R90 RF_DRV1.n0 RF_DRV1.t2 45.5434
R91 RF_DRV1.n0 RF_DRV1.t0 33.5789
R92 RF_DRV1.n1 RF_DRV1.t1 33.1732
R93 RF_DRV1 RF_DRV1.n1 9.0005
R94 RF_DRV1.n1 RF_DRV1.n0 0.377079
R95 VDD.n32 VDD.t0 60.6623
R96 VDD.n32 VDD.n31 12.6005
R97 VDD.n32 VDD.n1 12.6005
R98 VDD.n32 VDD.n28 12.6005
R99 VDD.n32 VDD.n2 12.6005
R100 VDD.n32 VDD.n23 12.6005
R101 VDD.n32 VDD.n3 12.6005
R102 VDD.n32 VDD.n19 12.6005
R103 VDD.n32 VDD.n15 12.6005
R104 VDD.n32 VDD.n5 12.6005
R105 VDD.n32 VDD.n11 12.6005
R106 VDD.t23 VDD.t25 11.0299
R107 VDD.t12 VDD.t23 7.35344
R108 VDD.t5 VDD.t12 6.06668
R109 VDD.n34 VDD.t26 4.29331
R110 VDD.n32 VDD.n4 4.00858
R111 VDD.n32 VDD.n8 2.88791
R112 VDD.n0 VDD.t24 2.73329
R113 VDD.n10 VDD.t20 2.33099
R114 VDD.n9 VDD.t13 2.33099
R115 VDD.n32 VDD.n6 2.19588
R116 VDD.n33 VDD.n32 2.19588
R117 VDD.n14 VDD.t15 1.98179
R118 VDD.n18 VDD.t16 1.94867
R119 VDD.n31 VDD.t21 1.93874
R120 VDD.n7 VDD.t22 1.90049
R121 VDD.n20 VDD.t1 1.90049
R122 VDD.t0 VDD.t9 1.83874
R123 VDD.n13 VDD.n12 1.35157
R124 VDD.n17 VDD.n16 1.33617
R125 VDD.n22 VDD.n21 1.33617
R126 VDD.n27 VDD.n26 1.31249
R127 VDD.n25 VDD.n24 1.31249
R128 VDD.n30 VDD.n29 1.31249
R129 VDD.t9 VDD.t5 1.28726
R130 VDD.n7 VDD.n6 1.20754
R131 VDD.n33 VDD.n0 1.16704
R132 VDD.n6 VDD.n0 0.94066
R133 VDD.n34 VDD.n33 0.83491
R134 VDD.n10 VDD.n8 0.745235
R135 VDD.n8 VDD.n7 0.710646
R136 VDD.n18 VDD.n4 0.645398
R137 VDD.n13 VDD.n4 0.496534
R138 VDD.n14 VDD.n5 0.44375
R139 VDD.n12 VDD.t19 0.390639
R140 VDD.n12 VDD.t6 0.390639
R141 VDD.n15 VDD.n13 0.38975
R142 VDD.n23 VDD.n22 0.38525
R143 VDD.n16 VDD.t17 0.379667
R144 VDD.n16 VDD.t18 0.379667
R145 VDD.n21 VDD.t10 0.379667
R146 VDD.n21 VDD.t11 0.379667
R147 VDD.n26 VDD.t2 0.3645
R148 VDD.n26 VDD.t7 0.3645
R149 VDD.n24 VDD.t4 0.3645
R150 VDD.n24 VDD.t14 0.3645
R151 VDD.n29 VDD.t3 0.3645
R152 VDD.n29 VDD.t8 0.3645
R153 VDD.n9 VDD.n5 0.36275
R154 VDD.n31 VDD.n30 0.35825
R155 VDD.n11 VDD.n10 0.34475
R156 VDD.n23 VDD.n20 0.32675
R157 VDD.n17 VDD.n3 0.29525
R158 VDD.n27 VDD.n2 0.27275
R159 VDD.n25 VDD.n1 0.26825
R160 VDD.n19 VDD.n18 0.24125
R161 VDD.n28 VDD.n25 0.18275
R162 VDD.n28 VDD.n27 0.17825
R163 VDD.n19 VDD.n17 0.15575
R164 VDD.n20 VDD.n2 0.12425
R165 VDD.n30 VDD.n1 0.09275
R166 VDD.n11 VDD.n9 0.08825
R167 VDD.n22 VDD.n3 0.06575
R168 VDD VDD.n34 0.03875
R169 VDD.n15 VDD.n14 0.00725
R170 VSS.n101 VSS.t1 6506.57
R171 VSS.t24 VSS.n100 3671.77
R172 VSS.t23 VSS.t0 1799.37
R173 VSS.t1 VSS.t23 1714.47
R174 VSS.t0 VSS.t10 1622.26
R175 VSS.t71 VSS.t24 1356.6
R176 VSS.t10 VSS.t71 1268.05
R177 VSS.n83 VSS.n27 936.6
R178 VSS.n77 VSS.n27 936.6
R179 VSS.n72 VSS.n71 936.6
R180 VSS.n66 VSS.n65 936.6
R181 VSS.n65 VSS.n33 936.6
R182 VSS.n59 VSS.n58 936.6
R183 VSS.n58 VSS.n57 936.6
R184 VSS.n54 VSS.n53 936.6
R185 VSS.n53 VSS.n36 936.6
R186 VSS.n49 VSS.n36 936.6
R187 VSS.n49 VSS.n48 936.6
R188 VSS.n47 VSS.n38 936.6
R189 VSS.n42 VSS.n38 936.6
R190 VSS.n42 VSS.n41 936.6
R191 VSS.n41 VSS.n40 936.6
R192 VSS.n48 VSS.t74 908.501
R193 VSS.n71 VSS.t65 875.721
R194 VSS.n90 VSS.n89 866.053
R195 VSS.n57 VSS.t69 824.208
R196 VSS.n72 VSS.t4 697.768
R197 VSS.n40 VSS.t72 688.402
R198 VSS.n89 VSS.t61 557.278
R199 VSS.n59 VSS.t8 482.349
R200 VSS.t61 VSS.t63 374.64
R201 VSS.t13 VSS.t11 374.64
R202 VSS.t19 VSS.t21 374.64
R203 VSS.t21 VSS.t59 374.64
R204 VSS.t15 VSS.t17 374.64
R205 VSS.t17 VSS.t2 374.64
R206 VSS.t57 VSS.t67 374.64
R207 VSS.t8 VSS.t6 374.64
R208 VSS.n88 VSS.t11 369.957
R209 VSS.n70 VSS.t67 313.762
R210 VSS.n6 VSS.t55 259.981
R211 VSS.n66 VSS.t57 248.2
R212 VSS.n101 VSS.t72 248.2
R213 VSS.n76 VSS.t4 238.833
R214 VSS.n90 VSS.t25 216.822
R215 VSS.n84 VSS.t13 192.004
R216 VSS.t55 VSS.t53 186.514
R217 VSS.t49 VSS.t51 186.514
R218 VSS.t47 VSS.t45 186.514
R219 VSS.t45 VSS.t43 186.514
R220 VSS.t41 VSS.t39 186.514
R221 VSS.t35 VSS.t37 186.514
R222 VSS.t33 VSS.t35 186.514
R223 VSS.t31 VSS.t29 186.514
R224 VSS.t25 VSS.t27 186.514
R225 VSS.n84 VSS.t19 182.637
R226 VSS.t51 VSS.n10 156.206
R227 VSS.n95 VSS.t31 156.206
R228 VSS.t2 VSS.n76 135.808
R229 VSS.n11 VSS.t49 123.566
R230 VSS.t39 VSS.n99 123.566
R231 VSS.t29 VSS.n94 123.566
R232 VSS.n100 VSS.n1 118.903
R233 VSS.n54 VSS.t69 112.392
R234 VSS.t6 VSS.n33 79.6115
R235 VSS.n11 VSS.t47 62.9489
R236 VSS.n99 VSS.t37 62.9489
R237 VSS.n94 VSS.t27 62.9489
R238 VSS.t65 VSS.n70 60.8795
R239 VSS.n77 VSS.t15 51.5135
R240 VSS.n100 VSS.t41 37.3032
R241 VSS.n10 VSS.t53 30.309
R242 VSS.t43 VSS.n1 30.309
R243 VSS.n95 VSS.t33 30.309
R244 VSS.t74 VSS.n47 28.0985
R245 VSS.n10 VSS.n9 10.4005
R246 VSS.n12 VSS.n11 10.4005
R247 VSS.n14 VSS.n1 10.4005
R248 VSS.n99 VSS.n98 10.4005
R249 VSS.n96 VSS.n95 10.4005
R250 VSS.n94 VSS.n93 10.4005
R251 VSS.n91 VSS.n90 10.4005
R252 VSS.n89 VSS.n21 10.4005
R253 VSS.n88 VSS.n87 10.4005
R254 VSS.n85 VSS.n84 10.4005
R255 VSS.n83 VSS.n82 10.4005
R256 VSS.n80 VSS.n27 10.4005
R257 VSS.n78 VSS.n77 10.4005
R258 VSS.n76 VSS.n75 10.4005
R259 VSS.n73 VSS.n72 10.4005
R260 VSS.n71 VSS.n30 10.4005
R261 VSS.n70 VSS.n69 10.4005
R262 VSS.n67 VSS.n66 10.4005
R263 VSS.n65 VSS.n64 10.4005
R264 VSS.n62 VSS.n33 10.4005
R265 VSS.n60 VSS.n59 10.4005
R266 VSS.n58 VSS.n34 10.4005
R267 VSS.n57 VSS.n56 10.4005
R268 VSS.n55 VSS.n54 10.4005
R269 VSS.n53 VSS.n52 10.4005
R270 VSS.n51 VSS.n36 10.4005
R271 VSS.n50 VSS.n49 10.4005
R272 VSS.n48 VSS.n37 10.4005
R273 VSS.n47 VSS.n46 10.4005
R274 VSS.n44 VSS.n38 10.4005
R275 VSS.n43 VSS.n42 10.4005
R276 VSS.n41 VSS.n39 10.4005
R277 VSS.n40 VSS.n0 10.4005
R278 VSS.n102 VSS.n101 10.4005
R279 VSS.n103 VSS.t73 9.10471
R280 VSS.t63 VSS.n88 4.6835
R281 VSS.t59 VSS.n83 4.6835
R282 VSS.n45 VSS.t75 4.03076
R283 VSS.n63 VSS.t7 3.76313
R284 VSS.n61 VSS.t9 3.76313
R285 VSS.n32 VSS.t58 3.09644
R286 VSS.n35 VSS.t70 3.04534
R287 VSS.n81 VSS.t60 2.64609
R288 VSS.n79 VSS.t16 2.62155
R289 VSS.n74 VSS.t5 2.62155
R290 VSS.n6 VSS.t56 2.39335
R291 VSS.n92 VSS.t26 2.39335
R292 VSS.n68 VSS.n31 2.01721
R293 VSS.n29 VSS.n28 1.78155
R294 VSS.n23 VSS.n22 1.76497
R295 VSS.n86 VSS.n24 1.76497
R296 VSS.n26 VSS.n25 1.76497
R297 VSS.n8 VSS.n7 1.58695
R298 VSS.n5 VSS.n4 1.58695
R299 VSS.n13 VSS.n3 1.58695
R300 VSS.n15 VSS.n2 1.58695
R301 VSS.n97 VSS.n16 1.58695
R302 VSS.n18 VSS.n17 1.58695
R303 VSS.n20 VSS.n19 1.58695
R304 VSS.n31 VSS.t66 0.701999
R305 VSS.n31 VSS.t68 0.701999
R306 VSS.n22 VSS.t62 0.573227
R307 VSS.n22 VSS.t64 0.573227
R308 VSS.n24 VSS.t12 0.573227
R309 VSS.n24 VSS.t14 0.573227
R310 VSS.n25 VSS.t20 0.573227
R311 VSS.n25 VSS.t22 0.573227
R312 VSS.n28 VSS.t18 0.5465
R313 VSS.n28 VSS.t3 0.5465
R314 VSS.n7 VSS.t54 0.52466
R315 VSS.n7 VSS.t52 0.52466
R316 VSS.n4 VSS.t50 0.52466
R317 VSS.n4 VSS.t48 0.52466
R318 VSS.n3 VSS.t46 0.52466
R319 VSS.n3 VSS.t44 0.52466
R320 VSS.n2 VSS.t42 0.52466
R321 VSS.n2 VSS.t40 0.52466
R322 VSS.n16 VSS.t38 0.52466
R323 VSS.n16 VSS.t36 0.52466
R324 VSS.n17 VSS.t34 0.52466
R325 VSS.n17 VSS.t32 0.52466
R326 VSS.n19 VSS.t30 0.52466
R327 VSS.n19 VSS.t28 0.52466
R328 VSS.n91 VSS.n21 0.4505
R329 VSS.n73 VSS.n30 0.4505
R330 VSS.n69 VSS.n30 0.4505
R331 VSS.n60 VSS.n34 0.4505
R332 VSS.n56 VSS.n34 0.4505
R333 VSS.n56 VSS.n55 0.4505
R334 VSS.n52 VSS.n51 0.4505
R335 VSS.n51 VSS.n50 0.4505
R336 VSS.n50 VSS.n37 0.4505
R337 VSS.n46 VSS.n37 0.4505
R338 VSS.n44 VSS.n43 0.4505
R339 VSS.n43 VSS.n39 0.4505
R340 VSS.n39 VSS.n0 0.4505
R341 VSS.n102 VSS.n0 0.4505
R342 VSS.n64 VSS.n32 0.44825
R343 VSS.n68 VSS.n67 0.38975
R344 VSS.n52 VSS.n35 0.383
R345 VSS.n64 VSS.n63 0.36725
R346 VSS.n93 VSS.n92 0.36275
R347 VSS.n8 VSS.n5 0.3605
R348 VSS.n20 VSS.n18 0.3605
R349 VSS.n23 VSS.n21 0.35825
R350 VSS.n80 VSS.n79 0.35375
R351 VSS.n45 VSS.n44 0.3425
R352 VSS.n62 VSS.n61 0.34025
R353 VSS.n9 VSS.n6 0.33125
R354 VSS.n13 VSS.n12 0.33125
R355 VSS.n81 VSS.n80 0.33125
R356 VSS.n97 VSS.n96 0.29975
R357 VSS.n78 VSS.n29 0.29525
R358 VSS.n82 VSS.n26 0.27275
R359 VSS.n87 VSS.n86 0.26825
R360 VSS.n15 VSS.n14 0.24125
R361 VSS.n75 VSS.n74 0.23675
R362 VSS.n74 VSS.n73 0.21425
R363 VSS.n98 VSS.n15 0.20975
R364 VSS.n86 VSS.n85 0.18275
R365 VSS.n85 VSS.n26 0.17825
R366 VSS.n75 VSS.n29 0.15575
R367 VSS.n98 VSS.n97 0.15125
R368 VSS.n14 VSS.n13 0.11975
R369 VSS.n82 VSS.n81 0.11975
R370 VSS.n61 VSS.n60 0.11075
R371 VSS.n46 VSS.n45 0.1085
R372 VSS.n79 VSS.n78 0.09725
R373 VSS.n87 VSS.n23 0.09275
R374 VSS.n92 VSS.n91 0.08825
R375 VSS.n63 VSS.n62 0.08375
R376 VSS.n55 VSS.n35 0.068
R377 VSS.n9 VSS.n8 0.06125
R378 VSS.n96 VSS.n18 0.06125
R379 VSS.n69 VSS.n68 0.06125
R380 VSS VSS.n103 0.04325
R381 VSS.n12 VSS.n5 0.02975
R382 VSS.n93 VSS.n20 0.02975
R383 VSS.n67 VSS.n32 0.00275
R384 VSS.n103 VSS.n102 0.00275
R385 a_8006_200.t7 a_8006_200.n18 18.221
R386 a_8006_200.n18 a_8006_200.n19 0.280143
R387 a_8006_200.n19 a_8006_200.n21 0.527643
R388 a_8006_200.n21 a_8006_200.n22 5.98978
R389 a_8006_200.n22 a_8006_200.t6 0.379667
R390 a_8006_200.n22 a_8006_200.t9 0.379667
R391 a_8006_200.n21 a_8006_200.n20 5.51407
R392 a_8006_200.n20 a_8006_200.t8 0.379667
R393 a_8006_200.n20 a_8006_200.t5 0.379667
R394 a_8006_200.n19 a_8006_200.t4 6.12657
R395 a_8006_200.n18 a_8006_200.n14 0.563
R396 a_8006_200.n14 a_8006_200.n16 2.21193
R397 a_8006_200.n16 a_8006_200.n17 6.45885
R398 a_8006_200.n17 a_8006_200.t1 0.5465
R399 a_8006_200.n17 a_8006_200.t0 0.5465
R400 a_8006_200.n16 a_8006_200.n15 5.98313
R401 a_8006_200.n15 a_8006_200.t3 0.5465
R402 a_8006_200.n15 a_8006_200.t2 0.5465
R403 a_8006_200.n14 a_8006_200.n13 5.00514
R404 a_8006_200.n13 a_8006_200.n7 0.346289
R405 a_8006_200.n7 a_8006_200.n8 0.187513
R406 a_8006_200.n8 a_8006_200.n9 0.187513
R407 a_8006_200.n9 a_8006_200.n10 0.187513
R408 a_8006_200.n10 a_8006_200.n11 0.187513
R409 a_8006_200.n11 a_8006_200.n12 0.187513
R410 a_8006_200.n12 a_8006_200.t10 56.8107
R411 a_8006_200.n12 a_8006_200.t11 56.6237
R412 a_8006_200.n11 a_8006_200.t12 56.6237
R413 a_8006_200.n10 a_8006_200.t13 56.6237
R414 a_8006_200.n9 a_8006_200.t14 56.6237
R415 a_8006_200.n8 a_8006_200.t15 56.6237
R416 a_8006_200.n7 a_8006_200.t16 56.6237
R417 a_8006_200.n13 a_8006_200.n0 0.168658
R418 a_8006_200.n0 a_8006_200.n1 0.189974
R419 a_8006_200.n1 a_8006_200.n2 0.189974
R420 a_8006_200.n2 a_8006_200.n3 0.189974
R421 a_8006_200.n3 a_8006_200.n4 0.189974
R422 a_8006_200.n4 a_8006_200.n5 0.189974
R423 a_8006_200.n5 a_8006_200.n6 0.189974
R424 a_8006_200.n6 a_8006_200.t17 84.84
R425 a_8006_200.n6 a_8006_200.t18 84.6505
R426 a_8006_200.n5 a_8006_200.t19 84.6505
R427 a_8006_200.n4 a_8006_200.t20 84.6505
R428 a_8006_200.n3 a_8006_200.t21 84.6505
R429 a_8006_200.n2 a_8006_200.t22 84.6505
R430 a_8006_200.n1 a_8006_200.t23 84.6505
R431 a_8006_200.n0 a_8006_200.t24 84.6505
R432 a_7112_3000.t0 a_7112_3000.t1 23.3323
R433 a_5852_3000.t0 a_5852_3000.t1 23.3323
R434 a_4334_3000.t0 a_4334_3000.t1 23.3323
R435 a_2298_3000.t0 a_2298_3000.t1 23.3323
R436 a_392_3000.t0 a_392_3000.t1 23.3323
R437 a_6614_200.t2 a_6614_200.n10 32.3285
R438 a_6614_200.n10 a_6614_200.n11 0.187605
R439 a_6614_200.n11 a_6614_200.n12 0.189974
R440 a_6614_200.n12 a_6614_200.n13 0.189974
R441 a_6614_200.n13 a_6614_200.t12 82.2328
R442 a_6614_200.n13 a_6614_200.t13 82.0434
R443 a_6614_200.n12 a_6614_200.t14 82.0434
R444 a_6614_200.n11 a_6614_200.t15 82.0434
R445 a_6614_200.n10 a_6614_200.t16 82.0434
R446 a_6614_200.n10 a_6614_200.n0 0.332079
R447 a_6614_200.n0 a_6614_200.n7 0.147342
R448 a_6614_200.n7 a_6614_200.n8 0.189974
R449 a_6614_200.n8 a_6614_200.n9 0.189974
R450 a_6614_200.n9 a_6614_200.t8 58.7685
R451 a_6614_200.n9 a_6614_200.t9 58.5791
R452 a_6614_200.n8 a_6614_200.t10 58.5791
R453 a_6614_200.n7 a_6614_200.t11 58.5791
R454 a_6614_200.n0 a_6614_200.n6 5.66086
R455 a_6614_200.n6 a_6614_200.n4 1.42764
R456 a_6614_200.n4 a_6614_200.n5 6.7395
R457 a_6614_200.n5 a_6614_200.t3 0.701999
R458 a_6614_200.n5 a_6614_200.t6 0.701999
R459 a_6614_200.n4 a_6614_200.t5 7.29802
R460 a_6614_200.n6 a_6614_200.n1 0.788
R461 a_6614_200.n1 a_6614_200.n2 0.280143
R462 a_6614_200.n2 a_6614_200.n3 6.02581
R463 a_6614_200.n3 a_6614_200.t1 0.390639
R464 a_6614_200.n3 a_6614_200.t0 0.390639
R465 a_6614_200.n2 a_6614_200.t4 6.1289
R466 a_6614_200.n1 a_6614_200.t7 19.8924
R467 a_6500_3520.t0 a_6500_3520.t1 23.3323
R468 a_5514_200.t4 a_5514_200.n7 19.8924
R469 a_5514_200.n7 a_5514_200.n8 6.17262
R470 a_5514_200.n8 a_5514_200.t3 0.4555
R471 a_5514_200.n8 a_5514_200.t2 0.4555
R472 a_5514_200.n7 a_5514_200.n5 0.563
R473 a_5514_200.n5 a_5514_200.n6 8.659
R474 a_5514_200.n6 a_5514_200.t1 0.8195
R475 a_5514_200.n6 a_5514_200.t0 0.8195
R476 a_5514_200.n5 a_5514_200.n4 5.44871
R477 a_5514_200.n4 a_5514_200.n2 0.470632
R478 a_5514_200.n2 a_5514_200.n3 0.187513
R479 a_5514_200.n3 a_5514_200.t6 50.1625
R480 a_5514_200.n3 a_5514_200.t7 49.9755
R481 a_5514_200.n2 a_5514_200.t8 49.9755
R482 a_5514_200.n4 a_5514_200.n0 0.166289
R483 a_5514_200.n0 a_5514_200.n1 0.187605
R484 a_5514_200.n1 a_5514_200.t9 80.4078
R485 a_5514_200.n1 a_5514_200.t10 80.2184
R486 a_5514_200.n0 a_5514_200.t5 32.0665
R487 a_5514_200.n0 a_5514_200.t11 80.2184
R488 a_4982_3520.t0 a_4982_3520.t1 23.3323
R489 a_4156_200.t0 a_4156_200.n4 19.8924
R490 a_4156_200.n4 a_4156_200.t1 6.40539
R491 a_4156_200.n4 a_4156_200.n3 0.788
R492 a_4156_200.n3 a_4156_200.t2 8.67406
R493 a_4156_200.n3 a_4156_200.n2 6.1205
R494 a_4156_200.n2 a_4156_200.n1 0.384184
R495 a_4156_200.n1 a_4156_200.t4 45.7328
R496 a_4156_200.n1 a_4156_200.t5 45.5434
R497 a_4156_200.n2 a_4156_200.n0 0.332079
R498 a_4156_200.n0 a_4156_200.t6 71.8019
R499 a_4156_200.n0 a_4156_200.t3 32.7881
R500 a_4156_200.n0 a_4156_200.t7 71.6148
R501 a_2946_3520.t0 a_2946_3520.t1 23.3323
R502 a_1040_3520.t0 a_1040_3520.t1 23.3323
R503 a_n810_3520.t0 a_n810_3520.t1 23.3323
R504 a_2298_4040.t0 a_2298_4040.t1 23.3323
R505 a_392_4040.t0 a_392_4040.t1 23.3323
R506 a_2120_200.t1 a_2120_200.n0 33.8778
R507 a_2120_200.n0 a_2120_200.n1 0.211289
R508 a_2120_200.n1 a_2120_200.t4 52.5373
R509 a_2120_200.n1 a_2120_200.n3 7.21014
R510 a_2120_200.n3 a_2120_200.t3 9.88448
R511 a_2120_200.n3 a_2120_200.n2 0.563
R512 a_2120_200.n2 a_2120_200.t0 6.81188
R513 a_2120_200.n2 a_2120_200.t2 21.5639
R514 a_2120_200.n0 a_2120_200.t5 84.6505
R515 a_1040_4560.t0 a_1040_4560.t1 23.3323
R516 a_n810_4560.t0 a_n810_4560.t1 23.3323
R517 a_392_5080.t0 a_392_5080.t1 23.3323
R518 a_214_200.t0 a_214_200.n3 23.2353
R519 a_214_200.n3 a_214_200.t2 8.08769
R520 a_214_200.n3 a_214_200.n2 0.788
R521 a_214_200.n2 a_214_200.t3 14.7589
R522 a_214_200.n2 a_214_200.n1 7.00121
R523 a_214_200.n1 a_214_200.t4 40.8525
R524 a_214_200.n1 a_214_200.n0 0.377079
R525 a_214_200.n0 a_214_200.t1 33.6689
R526 a_214_200.n0 a_214_200.t5 61.1862
R527 a_n810_5600.t0 a_n810_5600.t1 23.3323
C0 D1 PA_DRAIN 1.02464f
C1 D1 VDD 4.09267f
C2 RF_DRV1 VDD 0.38892f
C3 PA_DRAIN VSS 6.79894f
C4 D1 VSS 6.81215f
C5 RF_DRV1 VSS 1.67002f
C6 VDD VSS 47.1233f
C7 a_n810_5600.t0 VSS 0.01049f
C8 a_n810_5600.t1 VSS 0.01049f
C9 a_214_200.t0 VSS 0.14271f
C10 a_214_200.t5 VSS 0.05819f
C11 a_214_200.n0 VSS 0.30976f
C12 a_214_200.t1 VSS 0.1782f
C13 a_214_200.t4 VSS 0.03119f
C14 a_214_200.n1 VSS 0.15452f
C15 a_214_200.n2 VSS 0.3131f
C16 a_214_200.t3 VSS 0.05581f
C17 a_214_200.n3 VSS 0.55778f
C18 a_214_200.t2 VSS 0.12021f
C19 a_392_5080.t0 VSS 0.06103f
C20 a_392_5080.t1 VSS 0.06103f
C21 a_n810_4560.t0 VSS 0.01755f
C22 a_n810_4560.t1 VSS 0.01755f
C23 a_1040_4560.t0 VSS 0.01846f
C24 a_1040_4560.t1 VSS 0.01846f
C25 a_2120_200.t1 VSS 0.20502f
C26 a_2120_200.n0 VSS 0.35621f
C27 a_2120_200.t5 VSS 0.09973f
C28 a_2120_200.n1 VSS 0.16469f
C29 a_2120_200.t2 VSS 0.12418f
C30 a_2120_200.n2 VSS 0.52202f
C31 a_2120_200.t0 VSS 0.24067f
C32 a_2120_200.t3 VSS 0.11453f
C33 a_2120_200.n3 VSS 0.37085f
C34 a_2120_200.t4 VSS 0.05188f
C35 a_392_4040.t0 VSS 0.06254f
C36 a_392_4040.t1 VSS 0.06254f
C37 a_2298_4040.t0 VSS 0.06094f
C38 a_2298_4040.t1 VSS 0.06094f
C39 a_n810_3520.t0 VSS 0.02163f
C40 a_n810_3520.t1 VSS 0.02163f
C41 a_1040_3520.t0 VSS 0.02911f
C42 a_1040_3520.t1 VSS 0.02911f
C43 a_2946_3520.t0 VSS 0.02233f
C44 a_2946_3520.t1 VSS 0.02233f
C45 a_4156_200.t0 VSS 0.10483f
C46 a_4156_200.n0 VSS 0.41402f
C47 a_4156_200.t7 VSS 0.08923f
C48 a_4156_200.t3 VSS 0.19282f
C49 a_4156_200.t6 VSS 0.08939f
C50 a_4156_200.n1 VSS 0.12681f
C51 a_4156_200.t5 VSS 0.04623f
C52 a_4156_200.t4 VSS 0.04643f
C53 a_4156_200.n2 VSS 0.08293f
C54 a_4156_200.n3 VSS 0.34337f
C55 a_4156_200.t2 VSS 0.2071f
C56 a_4156_200.n4 VSS 0.48124f
C57 a_4156_200.t1 VSS 0.44916f
C58 a_4982_3520.t0 VSS 0.02451f
C59 a_4982_3520.t1 VSS 0.02451f
C60 a_5514_200.t4 VSS 0.12936f
C61 a_5514_200.n0 VSS 0.36897f
C62 a_5514_200.t11 VSS 0.12776f
C63 a_5514_200.t5 VSS 0.20974f
C64 a_5514_200.t10 VSS 0.12776f
C65 a_5514_200.n1 VSS 0.17902f
C66 a_5514_200.t9 VSS 0.12795f
C67 a_5514_200.n2 VSS 0.11019f
C68 a_5514_200.t8 VSS 0.06582f
C69 a_5514_200.t7 VSS 0.06582f
C70 a_5514_200.n3 VSS 0.13466f
C71 a_5514_200.t6 VSS 0.06605f
C72 a_5514_200.n4 VSS 0.07824f
C73 a_5514_200.n5 VSS 0.37273f
C74 a_5514_200.t1 VSS 0.03297f
C75 a_5514_200.t0 VSS 0.03297f
C76 a_5514_200.n6 VSS 0.14253f
C77 a_5514_200.n7 VSS 0.56658f
C78 a_5514_200.t3 VSS 0.06594f
C79 a_5514_200.t2 VSS 0.06594f
C80 a_5514_200.n8 VSS 0.27483f
C81 a_6500_3520.t0 VSS 0.02803f
C82 a_6500_3520.t1 VSS 0.02803f
C83 a_6614_200.t2 VSS 0.20048f
C84 a_6614_200.n0 VSS 0.06071f
C85 a_6614_200.t7 VSS 0.11777f
C86 a_6614_200.n1 VSS 0.45289f
C87 a_6614_200.t4 VSS 0.46363f
C88 a_6614_200.n2 VSS 0.16748f
C89 a_6614_200.t1 VSS 0.07001f
C90 a_6614_200.t0 VSS 0.07001f
C91 a_6614_200.n3 VSS 0.29918f
C92 a_6614_200.t5 VSS 0.19384f
C93 a_6614_200.n4 VSS 0.20832f
C94 a_6614_200.t3 VSS 0.03504f
C95 a_6614_200.t6 VSS 0.03504f
C96 a_6614_200.n5 VSS 0.12832f
C97 a_6614_200.n6 VSS 0.23739f
C98 a_6614_200.n7 VSS 0.07561f
C99 a_6614_200.t11 VSS 0.07594f
C100 a_6614_200.t10 VSS 0.07594f
C101 a_6614_200.n8 VSS 0.07109f
C102 a_6614_200.t9 VSS 0.07594f
C103 a_6614_200.n9 VSS 0.13276f
C104 a_6614_200.t8 VSS 0.07614f
C105 a_6614_200.n10 VSS 0.37033f
C106 a_6614_200.t16 VSS 0.11953f
C107 a_6614_200.t15 VSS 0.11953f
C108 a_6614_200.n11 VSS 0.08728f
C109 a_6614_200.t14 VSS 0.11953f
C110 a_6614_200.n12 VSS 0.0874f
C111 a_6614_200.t13 VSS 0.11953f
C112 a_6614_200.n13 VSS 0.1654f
C113 a_6614_200.t12 VSS 0.11971f
C114 a_392_3000.t0 VSS 0.06811f
C115 a_392_3000.t1 VSS 0.06811f
C116 a_2298_3000.t0 VSS 0.068f
C117 a_2298_3000.t1 VSS 0.068f
C118 a_4334_3000.t0 VSS 0.06831f
C119 a_4334_3000.t1 VSS 0.06831f
C120 a_5852_3000.t0 VSS 0.06989f
C121 a_5852_3000.t1 VSS 0.06989f
C122 a_7112_3000.t0 VSS 0.06999f
C123 a_7112_3000.t1 VSS 0.06999f
C124 a_8006_200.t7 VSS 0.0947f
C125 a_8006_200.n0 VSS 0.10126f
C126 a_8006_200.t24 VSS 0.13183f
C127 a_8006_200.t23 VSS 0.13183f
C128 a_8006_200.n1 VSS 0.09439f
C129 a_8006_200.t22 VSS 0.13183f
C130 a_8006_200.n2 VSS 0.09439f
C131 a_8006_200.t21 VSS 0.13183f
C132 a_8006_200.n3 VSS 0.09439f
C133 a_8006_200.t20 VSS 0.13183f
C134 a_8006_200.n4 VSS 0.09439f
C135 a_8006_200.t19 VSS 0.13183f
C136 a_8006_200.n5 VSS 0.09439f
C137 a_8006_200.t18 VSS 0.13183f
C138 a_8006_200.n6 VSS 0.17883f
C139 a_8006_200.t17 VSS 0.13202f
C140 a_8006_200.n7 VSS 0.09866f
C141 a_8006_200.t16 VSS 0.07686f
C142 a_8006_200.t15 VSS 0.07686f
C143 a_8006_200.n8 VSS 0.07454f
C144 a_8006_200.t14 VSS 0.07686f
C145 a_8006_200.n9 VSS 0.07454f
C146 a_8006_200.t13 VSS 0.07686f
C147 a_8006_200.n10 VSS 0.07454f
C148 a_8006_200.t12 VSS 0.07686f
C149 a_8006_200.n11 VSS 0.07454f
C150 a_8006_200.t11 VSS 0.07686f
C151 a_8006_200.n12 VSS 0.13897f
C152 a_8006_200.t10 VSS 0.07707f
C153 a_8006_200.n13 VSS 0.05636f
C154 a_8006_200.n14 VSS 0.2239f
C155 a_8006_200.t3 VSS 0.04773f
C156 a_8006_200.t2 VSS 0.04773f
C157 a_8006_200.n15 VSS 0.17957f
C158 a_8006_200.n16 VSS 0.23931f
C159 a_8006_200.t1 VSS 0.04773f
C160 a_8006_200.t0 VSS 0.04773f
C161 a_8006_200.n17 VSS 0.18428f
C162 a_8006_200.n18 VSS 0.32017f
C163 a_8006_200.t4 VSS 0.50723f
C164 a_8006_200.n19 VSS 0.11889f
C165 a_8006_200.t8 VSS 0.07637f
C166 a_8006_200.t5 VSS 0.07637f
C167 a_8006_200.n20 VSS 0.32076f
C168 a_8006_200.n21 VSS 0.14582f
C169 a_8006_200.t6 VSS 0.07637f
C170 a_8006_200.t9 VSS 0.07637f
C171 a_8006_200.n22 VSS 0.32582f
C172 VDD.t26 VSS 0.05084f
C173 VDD.t24 VSS 0.08143f
C174 VDD.n0 VSS 0.16989f
C175 VDD.n4 VSS 0.02086f
C176 VDD.n5 VSS 0.02371f
C177 VDD.n6 VSS 0.04952f
C178 VDD.t25 VSS 4.07977f
C179 VDD.t23 VSS 1.07362f
C180 VDD.t12 VSS 0.78374f
C181 VDD.t5 VSS 0.42945f
C182 VDD.t9 VSS 0.18252f
C183 VDD.t0 VSS 3.65032f
C184 VDD.t22 VSS 0.12332f
C185 VDD.n7 VSS 0.16377f
C186 VDD.n8 VSS 0.02655f
C187 VDD.t13 VSS 0.10003f
C188 VDD.n9 VSS 0.09818f
C189 VDD.t20 VSS 0.10003f
C190 VDD.n10 VSS 0.12615f
C191 VDD.n11 VSS 0.01061f
C192 VDD.t19 VSS 0.02394f
C193 VDD.t6 VSS 0.02394f
C194 VDD.n12 VSS 0.08103f
C195 VDD.n13 VSS 0.08461f
C196 VDD.t15 VSS 0.11653f
C197 VDD.n14 VSS 0.10137f
C198 VDD.t17 VSS 0.02463f
C199 VDD.t18 VSS 0.02463f
C200 VDD.n16 VSS 0.08186f
C201 VDD.n17 VSS 0.06464f
C202 VDD.t16 VSS 0.11929f
C203 VDD.n18 VSS 0.11966f
C204 VDD.t1 VSS 0.12332f
C205 VDD.n20 VSS 0.1007f
C206 VDD.t10 VSS 0.02463f
C207 VDD.t11 VSS 0.02463f
C208 VDD.n21 VSS 0.08186f
C209 VDD.n22 VSS 0.06464f
C210 VDD.n23 VSS 0.0204f
C211 VDD.t4 VSS 0.02566f
C212 VDD.t14 VSS 0.02566f
C213 VDD.n24 VSS 0.08304f
C214 VDD.n25 VSS 0.06401f
C215 VDD.t2 VSS 0.02566f
C216 VDD.t7 VSS 0.02566f
C217 VDD.n26 VSS 0.08304f
C218 VDD.n27 VSS 0.06401f
C219 VDD.t21 VSS 0.12534f
C220 VDD.t3 VSS 0.02566f
C221 VDD.t8 VSS 0.02566f
C222 VDD.n29 VSS 0.08304f
C223 VDD.n30 VSS 0.06401f
C224 VDD.n31 VSS 0.10984f
C225 VDD.n32 VSS 4.70853f
C226 VDD.n33 VSS 0.04325f
C227 VDD.n34 VSS 0.11894f
C228 RF_DRV1.t0 VSS 0.14697f
C229 RF_DRV1.t2 VSS 0.03138f
C230 RF_DRV1.n0 VSS 0.24934f
C231 RF_DRV1.t1 VSS 0.01796f
C232 RF_DRV1.n1 VSS 0.11699f
C233 D1.t6 VSS 0.07321f
C234 D1.t0 VSS 0.07321f
C235 D1.n0 VSS 0.31286f
C236 D1.t8 VSS 0.07321f
C237 D1.t1 VSS 0.07321f
C238 D1.n1 VSS 0.30809f
C239 D1.n2 VSS 0.1346f
C240 D1.t7 VSS 0.07321f
C241 D1.t3 VSS 0.07321f
C242 D1.n3 VSS 0.30809f
C243 D1.n4 VSS 0.07914f
C244 D1.t12 VSS 0.07321f
C245 D1.t2 VSS 0.07321f
C246 D1.n5 VSS 0.30809f
C247 D1.n6 VSS 0.12582f
C248 D1.t10 VSS 0.04188f
C249 D1.t11 VSS 0.04188f
C250 D1.n7 VSS 0.16084f
C251 D1.t5 VSS 0.04188f
C252 D1.t9 VSS 0.04188f
C253 D1.n8 VSS 0.1566f
C254 D1.n9 VSS 0.12958f
C255 D1.t14 VSS 0.04188f
C256 D1.t4 VSS 0.04188f
C257 D1.n10 VSS 0.1566f
C258 D1.n11 VSS 0.07858f
C259 D1.t13 VSS 0.24298f
C260 D1.n12 VSS 0.16723f
C261 D1.n13 VSS 0.22245f
C262 D1.t15 VSS 0.07718f
C263 D1.t16 VSS 0.07699f
C264 D1.n14 VSS 0.13163f
C265 D1.t17 VSS 0.07699f
C266 D1.n15 VSS 0.0704f
C267 D1.t18 VSS 0.07699f
C268 D1.n16 VSS 0.0704f
C269 D1.t19 VSS 0.07699f
C270 D1.n17 VSS 0.0704f
C271 D1.t20 VSS 0.07699f
C272 D1.n18 VSS 0.0704f
C273 D1.t21 VSS 0.07699f
C274 D1.n19 VSS 0.0704f
C275 D1.t22 VSS 0.07699f
C276 D1.n20 VSS 0.0704f
C277 D1.t23 VSS 0.07699f
C278 D1.n21 VSS 0.0704f
C279 D1.t24 VSS 0.07699f
C280 D1.n22 VSS 0.0704f
C281 D1.t25 VSS 0.07699f
C282 D1.n23 VSS 0.0704f
C283 D1.t26 VSS 0.07699f
C284 D1.n24 VSS 0.0704f
C285 D1.t27 VSS 0.07699f
C286 D1.n25 VSS 0.0704f
C287 D1.t28 VSS 0.07699f
C288 D1.n26 VSS 0.0704f
C289 D1.t29 VSS 0.07699f
C290 D1.n27 VSS 0.0704f
C291 D1.t30 VSS 0.07699f
C292 PA_DRAIN.t2 VSS 0.01202f
C293 PA_DRAIN.t5 VSS 0.01202f
C294 PA_DRAIN.t0 VSS 0.01202f
C295 PA_DRAIN.t11 VSS 0.01202f
C296 PA_DRAIN.n2 VSS 0.15019f
C297 PA_DRAIN.t6 VSS 0.01202f
C298 PA_DRAIN.t8 VSS 0.01202f
C299 PA_DRAIN.n4 VSS 0.08858f
C300 PA_DRAIN.t12 VSS 0.01202f
C301 PA_DRAIN.t3 VSS 0.01202f
C302 PA_DRAIN.n6 VSS 0.08858f
C303 PA_DRAIN.t13 VSS 0.01202f
C304 PA_DRAIN.t15 VSS 0.01202f
C305 PA_DRAIN.n8 VSS 0.08858f
C306 PA_DRAIN.t14 VSS 0.01202f
C307 PA_DRAIN.t1 VSS 0.01202f
C308 PA_DRAIN.n10 VSS 0.08858f
C309 PA_DRAIN.t7 VSS 0.01202f
C310 PA_DRAIN.t9 VSS 0.01202f
C311 PA_DRAIN.n12 VSS 0.08858f
C312 PA_DRAIN.t10 VSS 0.01202f
C313 PA_DRAIN.t4 VSS 0.01202f
C314 PA_DRAIN.n14 VSS 0.10856f
.ends
