* NGSPICE file created from LOOP_PART.ext - technology: gf180mcuE

.subckt LOOP_PART VDD_VCO VDD VSS UPB DN CP_IBIAS TAIL_BIAS REF_1M FB_1M VCTRL
X0 a_31212_n4894.t93 VSS.t77 cap_nmos_03v3 c_width=20.4u c_length=6u
X1 a_31212_n4894.t167 VSS.t171 cap_nmos_03v3 c_width=20.4u c_length=6u
X2 TAIL_BIAS.t5 VSS.t153 cap_nmos_03v3 c_width=20u c_length=6u
X3 VDD.t109 a_3032_n194.t53 VDD_VCO.t40 VDD.t108 pfet_03v3 ad=1.04p pd=4.52u as=1.04p ps=4.52u w=4u l=0.28u
X4 a_31212_n4894.t59 VSS.t29 cap_nmos_03v3 c_width=20.4u c_length=6u
X5 a_9736_n12398.t1 a_13712_n12918.t1 VSS.t33 ppolyf_u_1k r_width=1u r_length=19.24u
X6 a_31212_n8014.t1 a_34356_n7494.t1 VSS.t0 ppolyf_u_1k r_width=1u r_length=15.08u
X7 VDD.t15 VSS.t275 a_19036_6374.t1 VDD.t14 pfet_03v3 ad=0.728p pd=3.54u as=0.448p ps=2.8u w=1.12u l=0.28u
X8 a_31212_n14254.t1 a_34356_n13734.t0 VSS.t0 ppolyf_u_1k r_width=1u r_length=15.08u
X9 a_31212_n4894.t99 VSS.t83 cap_nmos_03v3 c_width=20.4u c_length=6u
X10 VDD_VCO.t27 a_3032_n194.t40 VDD.t80 VDD.t79 pfet_03v3 ad=1.04p pd=4.52u as=1.04p ps=4.52u w=4u l=0.28u
X11 VDD.t115 FB_1M.t2 UPB.t1 VDD.t114 pfet_03v3 ad=0.728p pd=3.54u as=0.728p ps=3.54u w=1.12u l=0.28u
X12 a_31212_n4894.t63 VSS.t214 cap_nmos_03v3 c_width=20.4u c_length=6u
X13 VDD_VCO.t50 VSS.t254 cap_nmos_03v3 c_width=10u c_length=6u
X14 a_31212_n4894.t194 VSS.t237 cap_nmos_03v3 c_width=20.4u c_length=6u
X15 a_31212_n4894.t170 VSS.t174 cap_nmos_03v3 c_width=20.4u c_length=6u
X16 a_31212_n4894.t26 VSS.t110 cap_nmos_03v3 c_width=20.4u c_length=6u
X17 VSS.t36 a_13714_n17054.t6 a_9736_n9958.t3 VSS.t35 nfet_03v3 ad=3.66p pd=13.22u as=1.56p ps=6.52u w=6u l=1.5u
X18 a_31212_n11134.t1 a_34356_n10614.t1 VSS.t0 ppolyf_u_1k r_width=1u r_length=15.08u
X19 a_31212_n4894.t40 VSS.t92 cap_nmos_03v3 c_width=20.4u c_length=6u
X20 VDD.t25 a_3032_n194.t37 VDD_VCO.t6 VDD.t24 pfet_03v3 ad=1.04p pd=4.52u as=1.04p ps=4.52u w=4u l=0.28u
X21 a_9934_n17054.t0 a_3336_n8238.t3 a_13714_n17054.t0 VDD.t6 pfet_03v3 ad=3.9p pd=13.3u as=1.56p ps=6.52u w=6u l=1.5u
X22 a_31212_n4894.t29 VSS.t97 cap_nmos_03v3 c_width=20.4u c_length=6u
X23 a_31212_n4894.t153 VSS.t73 cap_nmos_03v3 c_width=20.4u c_length=6u
X24 a_31212_n4894.t134 VSS.t4 cap_nmos_03v3 c_width=20.4u c_length=6u
X25 VDD.t63 a_16794_6306.t4 DN.t0 VDD.t62 pfet_03v3 ad=0.728p pd=3.54u as=0.728p ps=3.54u w=1.12u l=0.28u
X26 VDD.t33 a_3032_n194.t9 VDD_VCO.t10 VDD.t32 pfet_03v3 ad=1.04p pd=4.52u as=1.04p ps=4.52u w=4u l=0.28u
X27 a_3032_n194.t1 a_9736_n9958.t7 VSS.t227 VSS.t226 nfet_03v3 ad=2.08p pd=8.52u as=4.88p ps=17.22u w=8u l=0.6u
X28 VDD.t31 a_3032_n194.t23 VDD_VCO.t9 VDD.t30 pfet_03v3 ad=1.04p pd=4.52u as=1.04p ps=4.52u w=4u l=0.28u
X29 a_31212_n4894.t86 VSS.t193 cap_nmos_03v3 c_width=20.4u c_length=6u
X30 a_9736_n10398.t1 a_10742_n10398.t1 VSS.t222 ppolyf_u_1k r_width=1u r_length=4.39u
X31 a_31212_n4894.t44 VSS.t112 cap_nmos_03v3 c_width=20.4u c_length=6u
X32 a_15736_n12398.t1 a_19136_n12918.t1 VSS.t230 ppolyf_u_1k r_width=1u r_length=16.36u
X33 a_31212_n4894.t173 VSS.t121 cap_nmos_03v3 c_width=20.4u c_length=6u
X34 a_31212_n4894.t42 VSS.t94 cap_nmos_03v3 c_width=20.4u c_length=6u
X35 TAIL_BIAS.t2 a_22018_6314.t3 VDD.t120 VDD.t105 pfet_03v3 ad=2.6p pd=9.3u as=2.6p ps=9.3u w=4u l=2u
X36 VDD.t5 REF_1M.t2 a_16794_6306.t0 VDD.t4 pfet_03v3 ad=0.728p pd=3.54u as=0.728p ps=3.54u w=1.12u l=0.28u
X37 a_9736_n12398.t0 a_13712_n11878.t0 VSS.t33 ppolyf_u_1k r_width=1u r_length=19.24u
X38 a_31212_n4894.t151 VSS.t71 cap_nmos_03v3 c_width=20.4u c_length=6u
X39 a_13714_n17054.t1 a_3336_n8238.t4 a_9934_n17054.t3 VDD.t41 pfet_03v3 ad=1.56p pd=6.52u as=3.9p ps=13.3u w=6u l=1.5u
X40 a_31212_n6974.t1 a_34356_n7494.t0 VSS.t0 ppolyf_u_1k r_width=1u r_length=15.08u
X41 a_31212_n4894.t66 VSS.t217 cap_nmos_03v3 c_width=20.4u c_length=6u
X42 VDD.t88 a_3032_n194.t29 VDD_VCO.t31 VDD.t87 pfet_03v3 ad=1.04p pd=4.52u as=1.04p ps=4.52u w=4u l=0.28u
X43 a_31212_n4894.t132 VSS.t2 cap_nmos_03v3 c_width=20.4u c_length=6u
X44 a_31212_n4894.t53 VSS.t23 cap_nmos_03v3 c_width=20.4u c_length=6u
X45 a_3032_n194.t4 a_10256_n9958.t1 cap_mim_2f0_m5m6_noshield c_width=28.7u c_length=87u
X46 a_20296_6374.t0 a_18976_6174.t3 VCTRL.t1 VDD.t76 pfet_03v3 ad=0.448p pd=2.8u as=1.5456p ps=5.86u w=2.24u l=1u
X47 a_3336_n11358.t0 a_7700_n11878.t1 VSS.t34 ppolyf_u_1k r_width=1u r_length=21.18u
X48 a_31212_n4894.t178 VSS.t126 cap_nmos_03v3 c_width=20.4u c_length=6u
X49 a_31212_n16334.t0 a_34356_n16854.t1 VSS.t0 ppolyf_u_1k r_width=1u r_length=15.08u
X50 a_3032_n194.t5 a_10256_n9958.t0 cap_mim_2f0_m5m6_noshield c_width=28.7u c_length=87u
X51 a_31212_n4894.t116 VSS.t42 cap_nmos_03v3 c_width=20.4u c_length=6u
X52 TAIL_BIAS.t1 TAIL_BIAS.t0 VSS.t157 VSS.t156 nfet_03v3 ad=0.61p pd=3.22u as=0.61p ps=3.22u w=1u l=5.6u
X53 UPB.t0 REF_1M.t1 a_15568_5748.t0 VSS.t19 nfet_03v3 ad=0.3416p pd=2.34u as=0.1456p ps=1.08u w=0.56u l=0.28u
X54 a_31212_n4894.t77 VSS.t137 cap_nmos_03v3 c_width=20.4u c_length=6u
X55 a_31212_n4894.t57 VSS.t27 cap_nmos_03v3 c_width=20.4u c_length=6u
X56 a_31212_n4894.t56 VSS.t26 cap_nmos_03v3 c_width=20.4u c_length=6u
X57 VDD_VCO.t21 a_3032_n194.t26 VDD.t61 VDD.t60 pfet_03v3 ad=1.04p pd=4.52u as=1.04p ps=4.52u w=4u l=0.28u
X58 a_31212_n4894.t130 VSS.t186 cap_nmos_03v3 c_width=20.4u c_length=6u
X59 a_31212_n4894.t25 VSS.t109 cap_nmos_03v3 c_width=20.4u c_length=6u
X60 a_15736_n10918.t0 VSS.t40 VSS.t39 ppolyf_u_1k r_width=1u r_length=15.03u
X61 a_31212_n4894.t164 VSS.t168 cap_nmos_03v3 c_width=20.4u c_length=6u
X62 a_31212_n4894.t83 VSS.t143 cap_nmos_03v3 c_width=20.4u c_length=6u
X63 a_31212_n4894.t96 VSS.t80 cap_nmos_03v3 c_width=20.4u c_length=6u
X64 VDD_VCO.t24 a_3032_n194.t48 VDD.t73 VDD.t72 pfet_03v3 ad=1.04p pd=4.52u as=1.04p ps=4.52u w=4u l=0.28u
X65 a_31212_n4894.t192 VSS.t235 cap_nmos_03v3 c_width=20.4u c_length=6u
X66 a_31212_n13214.t1 a_34356_n13734.t1 VSS.t0 ppolyf_u_1k r_width=1u r_length=15.08u
X67 a_3336_n10318.t0 a_7700_n9798.t0 VSS.t34 ppolyf_u_1k r_width=1u r_length=21.18u
X68 VDD.t8 a_3032_n194.t35 VDD_VCO.t1 VDD.t7 pfet_03v3 ad=1.04p pd=4.52u as=1.04p ps=4.52u w=4u l=0.28u
X69 VDD_VCO.t65 VSS.t239 cap_nmos_03v3 c_width=10u c_length=6u
X70 a_31212_n4894.t23 VSS.t107 cap_nmos_03v3 c_width=20.4u c_length=6u
X71 VDD_VCO.t59 VSS.t245 cap_nmos_03v3 c_width=10u c_length=6u
X72 a_9934_n17054.t2 a_17294_n17114.t2 a_9736_n9958.t1 VDD.t40 pfet_03v3 ad=3.9p pd=13.3u as=1.56p ps=6.52u w=6u l=1.5u
X73 VDD_VCO.t53 VSS.t251 cap_nmos_03v3 c_width=10u c_length=6u
X74 a_15736_n12398.t0 a_3336_n8238.t2 VSS.t228 ppolyf_u_1k r_width=1u r_length=16.36u
X75 a_31212_n4894.t154 VSS.t74 cap_nmos_03v3 c_width=20.4u c_length=6u
X76 a_31212_n4894.t135 VSS.t5 cap_nmos_03v3 c_width=20.4u c_length=6u
X77 a_9934_n17054.t5 a_2982_n17114.t4 VDD.t71 VDD.t70 pfet_03v3 ad=2.08p pd=8.52u as=5.2p ps=17.3u w=8u l=1u
X78 a_31212_n4894.t111 VSS.t14 cap_nmos_03v3 c_width=20.4u c_length=6u
X79 a_31212_n4894.t145 VSS.t133 cap_nmos_03v3 c_width=20.4u c_length=6u
X80 a_31212_n4894.t72 VSS.t164 cap_nmos_03v3 c_width=20.4u c_length=6u
X81 VDD_VCO.t35 a_3032_n194.t32 VDD.t96 VDD.t95 pfet_03v3 ad=1.04p pd=4.52u as=1.04p ps=4.52u w=4u l=0.28u
X82 a_31212_n4894.t107 VSS.t206 cap_nmos_03v3 c_width=20.4u c_length=6u
X83 VDD_VCO.t28 a_3032_n194.t54 VDD.t82 VDD.t81 pfet_03v3 ad=1.04p pd=4.52u as=2.6p ps=9.3u w=4u l=0.28u
X84 VCTRL.t0 a_34356_n18934.t0 VSS.t0 ppolyf_u_1k r_width=1u r_length=15.08u
X85 a_31212_n4894.t38 VSS.t90 cap_nmos_03v3 c_width=20.4u c_length=6u
X86 a_31212_n4894.t78 VSS.t138 cap_nmos_03v3 c_width=20.4u c_length=6u
X87 a_31212_n4894.t91 VSS.t198 cap_nmos_03v3 c_width=20.4u c_length=6u
X88 a_31212_n4894.t74 VSS.t166 cap_nmos_03v3 c_width=20.4u c_length=6u
X89 a_31212_n4894.t143 VSS.t131 cap_nmos_03v3 c_width=20.4u c_length=6u
X90 a_31212_n4894.t159 VSS.t63 cap_nmos_03v3 c_width=20.4u c_length=6u
X91 VSS.t179 a_13714_n17054.t4 a_13714_n17054.t5 VSS.t178 nfet_03v3 ad=3.66p pd=13.22u as=1.56p ps=6.52u w=6u l=1.5u
X92 VSS.t268 a_31212_n4894.t7 cap_mim_2f0_m5m6_noshield c_width=28.16u c_length=80.64u
X93 a_31212_n4894.t124 VSS.t180 cap_nmos_03v3 c_width=20.4u c_length=6u
X94 a_31212_n16334.t1 a_34356_n15814.t0 VSS.t0 ppolyf_u_1k r_width=1u r_length=15.08u
X95 a_31212_n4894.t36 VSS.t88 cap_nmos_03v3 c_width=20.4u c_length=6u
X96 a_3336_n11358.t1 a_7700_n10838.t1 VSS.t34 ppolyf_u_1k r_width=1u r_length=21.18u
X97 a_31212_n10094.t0 a_34356_n9574.t0 VSS.t0 ppolyf_u_1k r_width=1u r_length=15.08u
X98 VDD.t55 a_3032_n194.t51 VDD_VCO.t18 VDD.t54 pfet_03v3 ad=1.04p pd=4.52u as=1.04p ps=4.52u w=4u l=0.28u
X99 a_16312_6176.t1 UPB.t3 VSS.t259 VSS.t176 nfet_03v3 ad=0.3416p pd=2.34u as=0.3416p ps=2.34u w=0.56u l=0.28u
X100 a_9736_n9958.t0 a_17294_n17114.t3 a_9934_n17054.t1 VDD.t26 pfet_03v3 ad=1.56p pd=6.52u as=3.9p ps=13.3u w=6u l=1.5u
X101 a_31212_n4894.t186 VSS.t56 cap_nmos_03v3 c_width=20.4u c_length=6u
X102 a_31212_n4894.t157 VSS.t61 cap_nmos_03v3 c_width=20.4u c_length=6u
X103 VDD_VCO.t62 VSS.t242 cap_nmos_03v3 c_width=10u c_length=6u
X104 a_9736_n11358.t0 a_13712_n11878.t1 VSS.t33 ppolyf_u_1k r_width=1u r_length=19.24u
X105 a_31212_n4894.t102 VSS.t201 cap_nmos_03v3 c_width=20.4u c_length=6u
X106 a_31212_n4894.t148 VSS.t68 cap_nmos_03v3 c_width=20.4u c_length=6u
X107 a_31212_n6974.t0 a_34356_n6454.t0 VSS.t0 ppolyf_u_1k r_width=1u r_length=15.08u
X108 VDD.t136 UPB.t5 a_20296_6374.t1 VDD.t135 pfet_03v3 ad=0.728p pd=3.54u as=0.448p ps=2.8u w=1.12u l=0.28u
X109 VDD_VCO.t47 a_3032_n194.t10 VDD.t130 VDD.t129 pfet_03v3 ad=1.04p pd=4.52u as=1.04p ps=4.52u w=4u l=0.28u
X110 a_31212_n4894.t129 VSS.t185 cap_nmos_03v3 c_width=20.4u c_length=6u
X111 a_21936_n12398.t1 a_25264_n12918.t1 VSS.t1 ppolyf_u_1k r_width=1u r_length=16u
X112 a_9736_n9958.t4 a_10256_n9958.t3 VSS.t258 ppolyf_u_1k r_width=1u r_length=1.96u
X113 a_31212_n4894.t69 VSS.t161 cap_nmos_03v3 c_width=20.4u c_length=6u
X114 a_13714_n17054.t3 a_13714_n17054.t2 VSS.t210 VSS.t209 nfet_03v3 ad=1.56p pd=6.52u as=3.66p ps=13.22u w=6u l=1.5u
X115 a_31212_n4894.t45 VSS.t113 cap_nmos_03v3 c_width=20.4u c_length=6u
X116 a_31212_n4894.t162 VSS.t66 cap_nmos_03v3 c_width=20.4u c_length=6u
X117 VDD_VCO.t55 VSS.t249 cap_nmos_03v3 c_width=10u c_length=6u
X118 a_22272_10590.t0 a_26120_10070.t0 VSS.t10 ppolyf_u_1k r_width=1u r_length=18.6u
X119 VSS.t31 a_9736_n9958.t6 a_3032_n194.t2 VSS.t30 nfet_03v3 ad=2.08p pd=8.52u as=2.08p ps=8.52u w=8u l=0.6u
X120 VSS.t269 a_31212_n4894.t6 cap_mim_2f0_m5m6_noshield c_width=28.16u c_length=80.64u
X121 a_31212_n4894.t184 VSS.t54 cap_nmos_03v3 c_width=20.4u c_length=6u
X122 VDD.t39 a_3032_n194.t7 VDD_VCO.t13 VDD.t38 pfet_03v3 ad=2.6p pd=9.3u as=1.04p ps=4.52u w=4u l=0.28u
X123 a_16794_6306.t2 FB_1M.t0 a_17394_5754.t2 VSS.t225 nfet_03v3 ad=0.3416p pd=2.34u as=0.1456p ps=1.08u w=0.56u l=0.28u
X124 VSS.t264 a_31212_n4894.t11 cap_mim_2f0_m5m6_noshield c_width=28.16u c_length=80.64u
X125 VDD.t35 a_3032_n194.t21 VDD_VCO.t11 VDD.t34 pfet_03v3 ad=1.04p pd=4.52u as=1.04p ps=4.52u w=4u l=0.28u
X126 a_16794_6306.t1 a_16312_6176.t2 a_17394_5754.t1 VSS.t32 nfet_03v3 ad=0.3416p pd=2.34u as=0.3416p ps=2.34u w=0.56u l=0.28u
X127 a_31212_n4894.t34 VSS.t102 cap_nmos_03v3 c_width=20.4u c_length=6u
X128 a_31212_n4894.t43 VSS.t95 cap_nmos_03v3 c_width=20.4u c_length=6u
X129 DN.t1 a_16794_6306.t3 VSS.t177 VSS.t176 nfet_03v3 ad=0.3416p pd=2.34u as=0.3416p ps=2.34u w=0.56u l=0.28u
X130 a_3336_n9278.t0 a_7700_n9798.t1 VSS.t34 ppolyf_u_1k r_width=1u r_length=21.18u
X131 a_22272_9550.t0 a_26120_9030.t0 VSS.t10 ppolyf_u_1k r_width=1u r_length=18.6u
X132 a_9736_n9958.t2 a_13714_n17054.t7 VSS.t38 VSS.t37 nfet_03v3 ad=1.56p pd=6.52u as=3.66p ps=13.22u w=6u l=1.5u
X133 a_18976_6174.t2 CP_IBIAS.t4 a_19148_5436.t0 VSS.t152 nfet_03v3 ad=0.728p pd=3.54u as=0.224p ps=1.68u w=1.12u l=1u
X134 a_31212_n4894.t47 VSS.t115 cap_nmos_03v3 c_width=20.4u c_length=6u
X135 a_31212_n4894.t32 VSS.t100 cap_nmos_03v3 c_width=20.4u c_length=6u
X136 a_31212_n4894.t182 VSS.t52 cap_nmos_03v3 c_width=20.4u c_length=6u
X137 VDD_VCO.t30 a_3032_n194.t18 VDD.t86 VDD.t85 pfet_03v3 ad=1.04p pd=4.52u as=1.04p ps=4.52u w=4u l=0.28u
X138 a_31212_n4894.t15 VSS.t147 cap_nmos_03v3 c_width=20.4u c_length=6u
X139 a_9736_n10398.t2 VCTRL.t3 a_9124_n19574.t2 VSS.t262 nfet_03v3 ad=4.88p pd=17.22u as=4.88p ps=17.22u w=8u l=1u
X140 a_21936_n10918.t0 VSS.t85 VSS.t1 ppolyf_u_1k r_width=1u r_length=16u
X141 VDD.t84 a_3032_n194.t27 VDD_VCO.t29 VDD.t83 pfet_03v3 ad=1.04p pd=4.52u as=1.04p ps=4.52u w=4u l=0.28u
X142 a_31212_n4894.t141 VSS.t129 cap_nmos_03v3 c_width=20.4u c_length=6u
X143 a_31212_n18414.t1 a_34356_n18934.t1 VSS.t0 ppolyf_u_1k r_width=1u r_length=15.08u
X144 a_31212_n4894.t110 VSS.t13 cap_nmos_03v3 c_width=20.4u c_length=6u
X145 a_9736_n11358.t1 a_2920_n19634.t2 VSS.t33 ppolyf_u_1k r_width=1u r_length=19.24u
X146 a_31212_n5934.t1 a_34356_n6454.t1 VSS.t0 ppolyf_u_1k r_width=1u r_length=15.08u
X147 a_31212_n4894.t187 VSS.t57 cap_nmos_03v3 c_width=20.4u c_length=6u
X148 CP_IBIAS.t2 CP_IBIAS.t1 a_19798_5436.t0 VSS.t152 nfet_03v3 ad=0.728p pd=3.54u as=0.224p ps=1.68u w=1.12u l=1u
X149 a_31212_n4894.t61 VSS.t212 cap_nmos_03v3 c_width=20.4u c_length=6u
X150 a_21936_n12398.t0 a_17294_n17114.t0 VSS.t1 ppolyf_u_1k r_width=1u r_length=16u
X151 TAIL_BIAS.t3 VSS.t155 cap_nmos_03v3 c_width=20u c_length=6u
X152 VDD_VCO.t5 a_3032_n194.t24 VDD.t21 VDD.t20 pfet_03v3 ad=1.04p pd=4.52u as=1.04p ps=4.52u w=4u l=0.28u
X153 a_31212_n4894.t24 VSS.t108 cap_nmos_03v3 c_width=20.4u c_length=6u
X154 a_3336_n10318.t1 a_7700_n10838.t0 VSS.t34 ppolyf_u_1k r_width=1u r_length=21.18u
X155 a_31212_n9054.t1 a_34356_n9574.t1 VSS.t0 ppolyf_u_1k r_width=1u r_length=15.08u
X156 a_31212_n4894.t165 VSS.t169 cap_nmos_03v3 c_width=20.4u c_length=6u
X157 VDD_VCO.t4 a_3032_n194.t46 VDD.t19 VDD.t18 pfet_03v3 ad=1.04p pd=4.52u as=1.04p ps=4.52u w=4u l=0.28u
X158 a_31212_n4894.t149 VSS.t69 cap_nmos_03v3 c_width=20.4u c_length=6u
X159 a_3032_n194.t6 a_10256_n9958.t2 cap_mim_2f0_m5m6_noshield c_width=28.7u c_length=87u
X160 a_31212_n4894.t28 VSS.t96 cap_nmos_03v3 c_width=20.4u c_length=6u
X161 a_31212_n4894.t146 VSS.t134 cap_nmos_03v3 c_width=20.4u c_length=6u
X162 a_31212_n4894.t39 VSS.t91 cap_nmos_03v3 c_width=20.4u c_length=6u
X163 a_31212_n4894.t82 VSS.t142 cap_nmos_03v3 c_width=20.4u c_length=6u
X164 a_31212_n4894.t115 VSS.t18 cap_nmos_03v3 c_width=20.4u c_length=6u
X165 a_31212_n4894.t127 VSS.t183 cap_nmos_03v3 c_width=20.4u c_length=6u
X166 VCTRL.t4 VSS.t261 cap_nmos_03v3 c_width=27u c_length=6u
X167 a_31212_n4894.t176 VSS.t124 cap_nmos_03v3 c_width=20.4u c_length=6u
X168 a_31212_n4894.t163 VSS.t67 cap_nmos_03v3 c_width=20.4u c_length=6u
X169 a_31212_n4894.t105 VSS.t204 cap_nmos_03v3 c_width=20.4u c_length=6u
X170 a_31212_n10094.t1 a_34356_n10614.t0 VSS.t0 ppolyf_u_1k r_width=1u r_length=15.08u
X171 VDD.t119 a_3032_n194.t43 VDD_VCO.t43 VDD.t118 pfet_03v3 ad=1.04p pd=4.52u as=1.04p ps=4.52u w=4u l=0.28u
X172 a_31212_n4894.t88 VSS.t195 cap_nmos_03v3 c_width=20.4u c_length=6u
X173 a_3336_n9278.t1 a_7700_n8758.t1 VSS.t34 ppolyf_u_1k r_width=1u r_length=21.18u
X174 VDD.t53 a_2982_n17114.t3 a_9934_n17054.t4 VDD.t52 pfet_03v3 ad=5.2p pd=17.3u as=2.08p ps=8.52u w=8u l=1u
X175 a_3032_n194.t3 a_9736_n9958.t5 VSS.t59 VSS.t58 nfet_03v3 ad=4.88p pd=17.22u as=2.08p ps=8.52u w=8u l=0.6u
X176 a_31212_n4894.t101 VSS.t200 cap_nmos_03v3 c_width=20.4u c_length=6u
X177 VDD_VCO.t37 a_3032_n194.t30 VDD.t100 VDD.t99 pfet_03v3 ad=1.04p pd=4.52u as=1.04p ps=4.52u w=4u l=0.28u
X178 a_19148_5436.t1 VDD.t138 VSS.t189 VSS.t188 nfet_03v3 ad=0.224p pd=1.68u as=0.3304p ps=2.3u w=0.56u l=0.28u
X179 VDD_VCO.t15 a_3032_n194.t52 VDD.t45 VDD.t44 pfet_03v3 ad=1.04p pd=4.52u as=1.04p ps=4.52u w=4u l=0.28u
X180 a_22272_9550.t1 a_26120_10070.t1 VSS.t10 ppolyf_u_1k r_width=1u r_length=18.6u
X181 a_31212_n4894.t68 VSS.t160 cap_nmos_03v3 c_width=20.4u c_length=6u
X182 VDD_VCO.t64 VSS.t240 cap_nmos_03v3 c_width=10u c_length=6u
X183 a_31212_n4894.t181 VSS.t51 cap_nmos_03v3 c_width=20.4u c_length=6u
X184 VDD_VCO.t58 VSS.t246 cap_nmos_03v3 c_width=10u c_length=6u
X185 a_31212_n4894.t168 VSS.t172 cap_nmos_03v3 c_width=20.4u c_length=6u
X186 a_31212_n4894.t87 VSS.t194 cap_nmos_03v3 c_width=20.4u c_length=6u
X187 VDD_VCO.t23 a_3032_n194.t16 VDD.t69 VDD.t68 pfet_03v3 ad=1.04p pd=4.52u as=1.04p ps=4.52u w=4u l=0.28u
X188 a_3336_n12918.t1 a_7700_n12918.t0 VSS.t34 ppolyf_u_1k r_width=1u r_length=21.18u
X189 a_31212_n4894.t144 VSS.t132 cap_nmos_03v3 c_width=20.4u c_length=6u
X190 a_31212_n4894.t125 VSS.t181 cap_nmos_03v3 c_width=20.4u c_length=6u
X191 a_31212_n4894.t52 VSS.t22 cap_nmos_03v3 c_width=20.4u c_length=6u
X192 VDD.t92 a_3032_n194.t49 VDD_VCO.t33 VDD.t91 pfet_03v3 ad=1.04p pd=4.52u as=1.04p ps=4.52u w=4u l=0.28u
X193 a_22272_8510.t1 a_26120_9030.t1 VSS.t10 ppolyf_u_1k r_width=1u r_length=18.6u
X194 a_31212_n4894.t71 VSS.t163 cap_nmos_03v3 c_width=20.4u c_length=6u
X195 a_31212_n4894.t106 VSS.t205 cap_nmos_03v3 c_width=20.4u c_length=6u
X196 a_31212_n4894.t20 VSS.t104 cap_nmos_03v3 c_width=20.4u c_length=6u
X197 a_31212_n4894.t67 VSS.t218 cap_nmos_03v3 c_width=20.4u c_length=6u
X198 a_19798_5436.t1 VDD.t137 VSS.t190 VSS.t188 nfet_03v3 ad=0.224p pd=1.68u as=0.3304p ps=2.3u w=0.56u l=0.28u
X199 VDD.t124 a_3032_n194.t13 VDD_VCO.t45 VDD.t123 pfet_03v3 ad=1.04p pd=4.52u as=1.04p ps=4.52u w=4u l=0.28u
X200 a_31212_n9054.t0 a_34356_n8534.t0 VSS.t0 ppolyf_u_1k r_width=1u r_length=15.08u
X201 a_31212_n4894.t55 VSS.t25 cap_nmos_03v3 c_width=20.4u c_length=6u
X202 a_31212_n13214.t0 a_34356_n12694.t0 VSS.t0 ppolyf_u_1k r_width=1u r_length=15.08u
X203 a_31212_n4894.t73 VSS.t165 cap_nmos_03v3 c_width=20.4u c_length=6u
X204 a_3032_n194.t0 a_2982_n17114.t5 VDD.t23 VDD.t22 pfet_03v3 ad=5.2p pd=17.3u as=5.2p ps=17.3u w=8u l=1u
X205 a_31212_n4894.t138 VSS.t8 cap_nmos_03v3 c_width=20.4u c_length=6u
X206 VDD_VCO.t36 a_3032_n194.t22 VDD.t98 VDD.t97 pfet_03v3 ad=1.04p pd=4.52u as=1.04p ps=4.52u w=4u l=0.28u
X207 a_15568_5748.t2 FB_1M.t1 VSS.t224 VSS.t223 nfet_03v3 ad=0.1456p pd=1.08u as=0.3416p ps=2.34u w=0.56u l=0.28u
X208 a_2920_n19634.t1 a_2920_n19634.t0 VSS.t159 VSS.t158 nfet_03v3 ad=2.44p pd=9.22u as=2.44p ps=9.22u w=4u l=1u
X209 VSS.t229 a_26120_12150.t1 VSS.t10 ppolyf_u_1k r_width=1u r_length=18.6u
X210 a_9736_n10398.t0 a_15128_n19574.t3 VDD.t113 VDD.t112 pfet_03v3 ad=5.2p pd=17.3u as=5.2p ps=17.3u w=8u l=1u
X211 a_31212_n4894.t22 VSS.t106 cap_nmos_03v3 c_width=20.4u c_length=6u
X212 a_31212_n5934.t0 a_34356_n5414.t0 VSS.t0 ppolyf_u_1k r_width=1u r_length=15.08u
X213 VDD_VCO.t49 VSS.t255 cap_nmos_03v3 c_width=10u c_length=6u
X214 a_31212_n4894.t147 VSS.t135 cap_nmos_03v3 c_width=20.4u c_length=6u
X215 a_31212_n4894.t193 VSS.t236 cap_nmos_03v3 c_width=20.4u c_length=6u
X216 VDD.t57 a_3032_n194.t19 VDD_VCO.t19 VDD.t56 pfet_03v3 ad=1.04p pd=4.52u as=1.04p ps=4.52u w=4u l=0.28u
X217 a_31212_n4894.t33 VSS.t101 cap_nmos_03v3 c_width=20.4u c_length=6u
X218 a_31212_n4894.t128 VSS.t184 cap_nmos_03v3 c_width=20.4u c_length=6u
X219 VDD.t59 a_3032_n194.t41 VDD_VCO.t20 VDD.t58 pfet_03v3 ad=1.04p pd=4.52u as=1.04p ps=4.52u w=4u l=0.28u
X220 a_31212_n4894.t119 VSS.t45 cap_nmos_03v3 c_width=20.4u c_length=6u
X221 VSS.t263 a_31212_n4894.t12 cap_mim_2f0_m5m6_noshield c_width=28.16u c_length=80.64u
X222 VSS.t266 a_31212_n4894.t9 cap_mim_2f0_m5m6_noshield c_width=28.16u c_length=80.64u
X223 a_31212_n4894.t37 VSS.t89 cap_nmos_03v3 c_width=20.4u c_length=6u
X224 a_31212_n4894.t112 VSS.t15 cap_nmos_03v3 c_width=20.4u c_length=6u
X225 a_31212_n4894.t152 VSS.t72 cap_nmos_03v3 c_width=20.4u c_length=6u
X226 a_22272_8510.t0 a_26120_7990.t1 VSS.t10 ppolyf_u_1k r_width=1u r_length=18.6u
X227 a_31212_n4894.t14 VSS.t146 cap_nmos_03v3 c_width=20.4u c_length=6u
X228 a_3336_n8238.t1 a_7700_n8758.t0 VSS.t34 ppolyf_u_1k r_width=1u r_length=21.18u
X229 VDD_VCO.t39 a_3032_n194.t38 VDD.t104 VDD.t103 pfet_03v3 ad=1.04p pd=4.52u as=1.04p ps=4.52u w=4u l=0.28u
X230 a_31212_n4894.t133 VSS.t3 cap_nmos_03v3 c_width=20.4u c_length=6u
X231 a_31212_n4894.t117 VSS.t43 cap_nmos_03v3 c_width=20.4u c_length=6u
X232 VDD.t126 a_9736_n10398.t3 a_3336_n12918.t3 VDD.t125 pfet_03v3 ad=3.9p pd=13.3u as=1.56p ps=6.52u w=6u l=1u
X233 VCTRL.t2 CP_IBIAS.t3 a_20408_5436.t0 VSS.t152 nfet_03v3 ad=0.728p pd=3.54u as=0.224p ps=1.68u w=1.12u l=1u
X234 a_31212_n4894.t51 VSS.t119 cap_nmos_03v3 c_width=20.4u c_length=6u
X235 VDD.t90 a_3032_n194.t25 VDD_VCO.t32 VDD.t89 pfet_03v3 ad=1.04p pd=4.52u as=1.04p ps=4.52u w=4u l=0.28u
X236 VSS.t267 a_31212_n4894.t8 cap_mim_2f0_m5m6_noshield c_width=28.16u c_length=80.64u
X237 VDD.t13 a_13712_n12918.t0 VSS.t33 ppolyf_u_1k r_width=1u r_length=19.24u
X238 a_31212_n4894.t179 VSS.t127 cap_nmos_03v3 c_width=20.4u c_length=6u
X239 VDD.t111 a_3032_n194.t47 VDD_VCO.t41 VDD.t110 pfet_03v3 ad=1.04p pd=4.52u as=1.04p ps=4.52u w=4u l=0.28u
X240 a_31212_n4894.t166 VSS.t170 cap_nmos_03v3 c_width=20.4u c_length=6u
X241 a_19036_6374.t0 a_18976_6174.t0 a_18976_6174.t1 VDD.t107 pfet_03v3 ad=0.448p pd=2.8u as=1.5456p ps=5.86u w=2.24u l=1u
X242 a_31212_n4894.t92 VSS.t76 cap_nmos_03v3 c_width=20.4u c_length=6u
X243 a_31212_n4894.t131 VSS.t187 cap_nmos_03v3 c_width=20.4u c_length=6u
X244 a_31212_n4894.t49 VSS.t117 cap_nmos_03v3 c_width=20.4u c_length=6u
X245 VDD_VCO.t61 VSS.t243 cap_nmos_03v3 c_width=10u c_length=6u
X246 a_31212_n4894.t18 VSS.t150 cap_nmos_03v3 c_width=20.4u c_length=6u
X247 VSS.t272 a_31212_n4894.t3 cap_mim_2f0_m5m6_noshield c_width=28.16u c_length=80.64u
X248 VDD_VCO.t63 VSS.t241 cap_nmos_03v3 c_width=10u c_length=6u
X249 a_31212_n4894.t122 VSS.t48 cap_nmos_03v3 c_width=20.4u c_length=6u
X250 a_31212_n4894.t90 VSS.t197 cap_nmos_03v3 c_width=20.4u c_length=6u
X251 a_31212_n15294.t1 a_34356_n15814.t1 VSS.t0 ppolyf_u_1k r_width=1u r_length=15.08u
X252 a_31212_n4894.t103 VSS.t202 cap_nmos_03v3 c_width=20.4u c_length=6u
X253 VDD_VCO.t34 a_3032_n194.t44 VDD.t94 VDD.t93 pfet_03v3 ad=1.04p pd=4.52u as=1.04p ps=4.52u w=4u l=0.28u
X254 VSS.t271 a_31212_n4894.t4 cap_mim_2f0_m5m6_noshield c_width=28.16u c_length=80.64u
X255 a_3336_n8238.t0 a_18870_n11438.t0 VSS.t41 ppolyf_u_1k r_width=1u r_length=15.03u
X256 a_2982_n17114.t0 a_2920_n19634.t5 VSS.t208 VSS.t207 nfet_03v3 ad=1.83p pd=7.22u as=1.83p ps=7.22u w=3u l=1u
X257 a_31212_n4894.t16 VSS.t148 cap_nmos_03v3 c_width=20.4u c_length=6u
X258 a_31212_n4894.t109 VSS.t12 cap_nmos_03v3 c_width=20.4u c_length=6u
X259 VSS.t270 a_31212_n4894.t5 cap_mim_2f0_m5m6_noshield c_width=28.16u c_length=80.64u
X260 a_31212_n4894.t70 VSS.t162 cap_nmos_03v3 c_width=20.4u c_length=6u
X261 a_31212_n8014.t0 a_34356_n8534.t1 VSS.t0 ppolyf_u_1k r_width=1u r_length=15.08u
X262 a_31212_n4894.t177 VSS.t125 cap_nmos_03v3 c_width=20.4u c_length=6u
X263 a_31212_n4894.t136 VSS.t6 cap_nmos_03v3 c_width=20.4u c_length=6u
X264 a_31212_n4894.t64 VSS.t215 cap_nmos_03v3 c_width=20.4u c_length=6u
X265 VDD_VCO.t60 VSS.t244 cap_nmos_03v3 c_width=10u c_length=6u
X266 a_31212_n12174.t0 a_34356_n12694.t1 VSS.t0 ppolyf_u_1k r_width=1u r_length=15.08u
X267 a_31212_n4894.t27 VSS.t111 cap_nmos_03v3 c_width=20.4u c_length=6u
X268 VDD.t29 a_19136_n12918.t0 VSS.t84 ppolyf_u_1k r_width=1u r_length=16.36u
X269 a_22272_11630.t1 a_26120_12150.t0 VSS.t10 ppolyf_u_1k r_width=1u r_length=18.6u
X270 a_31212_n4894.t62 VSS.t213 cap_nmos_03v3 c_width=20.4u c_length=6u
X271 a_31212_n4894.t31 VSS.t99 cap_nmos_03v3 c_width=20.4u c_length=6u
X272 VDD_VCO.t17 a_3032_n194.t50 VDD.t49 VDD.t48 pfet_03v3 ad=1.04p pd=4.52u as=1.04p ps=4.52u w=4u l=0.28u
X273 a_31212_n4894.t85 VSS.t192 cap_nmos_03v3 c_width=20.4u c_length=6u
X274 VDD_VCO.t52 VSS.t252 cap_nmos_03v3 c_width=10u c_length=6u
X275 a_31212_n4894.t160 VSS.t64 cap_nmos_03v3 c_width=20.4u c_length=6u
X276 a_22018_6314.t2 a_22018_6314.t1 VDD.t106 VDD.t105 pfet_03v3 ad=2.6p pd=9.3u as=2.6p ps=9.3u w=4u l=2u
X277 a_31212_n4894.t30 VSS.t98 cap_nmos_03v3 c_width=20.4u c_length=6u
X278 a_31212_n4894.t98 VSS.t82 cap_nmos_03v3 c_width=20.4u c_length=6u
X279 a_17394_5754.t0 REF_1M.t0 VSS.t21 VSS.t20 nfet_03v3 ad=0.1456p pd=1.08u as=0.3416p ps=2.34u w=0.56u l=0.28u
X280 a_31212_n4894.t81 VSS.t141 cap_nmos_03v3 c_width=20.4u c_length=6u
X281 a_31212_n4894.t190 VSS.t233 cap_nmos_03v3 c_width=20.4u c_length=6u
X282 a_3336_n12918.t4 a_10742_n10398.t0 cap_mim_2f0_m5m6_noshield c_width=28.7u c_length=38.5u
X283 VDD_VCO.t25 a_3032_n194.t14 VDD.t75 VDD.t74 pfet_03v3 ad=1.04p pd=4.52u as=1.04p ps=4.52u w=4u l=0.28u
X284 a_31212_n18414.t0 a_34356_n17894.t0 VSS.t0 ppolyf_u_1k r_width=1u r_length=15.08u
X285 a_31212_n4894.t104 VSS.t203 cap_nmos_03v3 c_width=20.4u c_length=6u
X286 a_31212_n4894.t65 VSS.t216 cap_nmos_03v3 c_width=20.4u c_length=6u
X287 a_31212_n4894.t100 VSS.t199 cap_nmos_03v3 c_width=20.4u c_length=6u
X288 a_31212_n4894.t180 VSS.t50 cap_nmos_03v3 c_width=20.4u c_length=6u
X289 VDD.t28 a_3032_n194.t11 VDD_VCO.t7 VDD.t27 pfet_03v3 ad=1.04p pd=4.52u as=1.04p ps=4.52u w=4u l=0.28u
X290 a_31212_n15294.t0 a_34356_n14774.t1 VSS.t0 ppolyf_u_1k r_width=1u r_length=15.08u
X291 VDD_VCO.t57 VSS.t247 cap_nmos_03v3 c_width=10u c_length=6u
X292 a_31212_n4894.t171 VSS.t175 cap_nmos_03v3 c_width=20.4u c_length=6u
X293 VDD.t102 a_3032_n194.t33 VDD_VCO.t38 VDD.t101 pfet_03v3 ad=1.04p pd=4.52u as=1.04p ps=4.52u w=4u l=0.28u
X294 a_2982_n17114.t2 a_2982_n17114.t1 VDD.t51 VDD.t50 pfet_03v3 ad=5.2p pd=17.3u as=5.2p ps=17.3u w=8u l=1u
X295 a_31212_n4894.t158 VSS.t62 cap_nmos_03v3 c_width=20.4u c_length=6u
X296 a_15736_n10918.t1 a_18870_n11438.t1 VSS.t221 ppolyf_u_1k r_width=1u r_length=15.03u
X297 a_31212_n4894.t60 VSS.t211 cap_nmos_03v3 c_width=20.4u c_length=6u
X298 a_3336_n12918.t0 a_2920_n19634.t3 VSS.t87 VSS.t86 nfet_03v3 ad=4.27p pd=15.22u as=4.27p ps=15.22u w=7u l=1u
X299 VDD_VCO.t42 a_3032_n194.t20 VDD.t117 VDD.t116 pfet_03v3 ad=1.04p pd=4.52u as=1.04p ps=4.52u w=4u l=0.28u
X300 a_31212_n4894.t139 VSS.t9 cap_nmos_03v3 c_width=20.4u c_length=6u
X301 a_31212_n4894.t76 VSS.t136 cap_nmos_03v3 c_width=20.4u c_length=6u
X302 a_31212_n4894.t123 VSS.t49 cap_nmos_03v3 c_width=20.4u c_length=6u
X303 a_31212_n12174.t1 a_34356_n11654.t1 VSS.t0 ppolyf_u_1k r_width=1u r_length=15.08u
X304 a_31212_n4894.t120 VSS.t46 cap_nmos_03v3 c_width=20.4u c_length=6u
X305 CP_IBIAS.t0 a_22018_6314.t4 VDD.t3 VDD.t2 pfet_03v3 ad=0.676p pd=3.38u as=0.676p ps=3.38u w=1.04u l=2u
X306 a_9124_n19574.t1 a_2920_n19634.t4 VSS.t257 VSS.t256 nfet_03v3 ad=1.83p pd=7.22u as=1.83p ps=7.22u w=3u l=1u
X307 a_31212_n4894.t185 VSS.t55 cap_nmos_03v3 c_width=20.4u c_length=6u
X308 a_31212_n4894.t169 VSS.t173 cap_nmos_03v3 c_width=20.4u c_length=6u
X309 a_31212_n4894.t58 VSS.t28 cap_nmos_03v3 c_width=20.4u c_length=6u
X310 a_31212_n4894.t95 VSS.t79 cap_nmos_03v3 c_width=20.4u c_length=6u
X311 a_31212_n4894.t156 VSS.t60 cap_nmos_03v3 c_width=20.4u c_length=6u
X312 a_22272_11630.t0 a_26120_11110.t0 VSS.t10 ppolyf_u_1k r_width=1u r_length=18.6u
X313 VDD.t1 a_3032_n194.t17 VDD_VCO.t0 VDD.t0 pfet_03v3 ad=1.04p pd=4.52u as=1.04p ps=4.52u w=4u l=0.28u
X314 a_31212_n4894.t41 VSS.t93 cap_nmos_03v3 c_width=20.4u c_length=6u
X315 a_31212_n4894.t137 VSS.t7 cap_nmos_03v3 c_width=20.4u c_length=6u
X316 VDD.t67 a_3032_n194.t39 VDD_VCO.t22 VDD.t66 pfet_03v3 ad=1.04p pd=4.52u as=1.04p ps=4.52u w=4u l=0.28u
X317 a_31212_n4894.t183 VSS.t53 cap_nmos_03v3 c_width=20.4u c_length=6u
X318 a_31212_n4894.t174 VSS.t122 cap_nmos_03v3 c_width=20.4u c_length=6u
X319 a_31212_n4894.t161 VSS.t65 cap_nmos_03v3 c_width=20.4u c_length=6u
X320 VDD_VCO.t2 a_3032_n194.t36 VDD.t12 VDD.t11 pfet_03v3 ad=1.04p pd=4.52u as=1.04p ps=4.52u w=4u l=0.28u
X321 a_31212_n4894.t142 VSS.t130 cap_nmos_03v3 c_width=20.4u c_length=6u
X322 a_31212_n4894.t118 VSS.t44 cap_nmos_03v3 c_width=20.4u c_length=6u
X323 a_31212_n4894.t50 VSS.t118 cap_nmos_03v3 c_width=20.4u c_length=6u
X324 a_31212_n4894.t19 VSS.t151 cap_nmos_03v3 c_width=20.4u c_length=6u
X325 a_31212_n4894.t188 VSS.t231 cap_nmos_03v3 c_width=20.4u c_length=6u
X326 a_17294_n17114.t1 a_25264_n11438.t1 VSS.t1 ppolyf_u_1k r_width=1u r_length=16u
X327 VDD.t17 a_3032_n194.t45 VDD_VCO.t3 VDD.t16 pfet_03v3 ad=1.04p pd=4.52u as=1.04p ps=4.52u w=4u l=0.28u
X328 VDD_VCO.t12 a_3032_n194.t8 VDD.t37 VDD.t36 pfet_03v3 ad=1.04p pd=4.52u as=1.04p ps=4.52u w=4u l=0.28u
X329 a_15128_n19574.t1 a_15128_n19574.t0 VDD.t10 VDD.t9 pfet_03v3 ad=5.2p pd=17.3u as=5.2p ps=17.3u w=8u l=1u
X330 a_31212_n4894.t54 VSS.t24 cap_nmos_03v3 c_width=20.4u c_length=6u
X331 TAIL_BIAS.t4 VSS.t154 cap_nmos_03v3 c_width=20u c_length=6u
X332 a_3336_n12918.t2 a_9736_n10398.t4 VDD.t65 VDD.t64 pfet_03v3 ad=1.56p pd=6.52u as=3.9p ps=13.3u w=6u l=1u
X333 a_31212_n4894.t84 VSS.t191 cap_nmos_03v3 c_width=20.4u c_length=6u
X334 a_31212_n17374.t1 a_34356_n17894.t1 VSS.t0 ppolyf_u_1k r_width=1u r_length=15.08u
X335 a_31212_n4894.t17 VSS.t149 cap_nmos_03v3 c_width=20.4u c_length=6u
X336 a_3336_n12398.t1 a_7700_n12918.t1 VSS.t34 ppolyf_u_1k r_width=1u r_length=21.18u
X337 a_31212_n4894.t150 VSS.t70 cap_nmos_03v3 c_width=20.4u c_length=6u
X338 UPB.t2 DN.t3 a_15568_5748.t1 VSS.t219 nfet_03v3 ad=0.3416p pd=2.34u as=0.3416p ps=2.34u w=0.56u l=0.28u
X339 a_31212_n4894.t0 a_34356_n5414.t1 VSS.t0 ppolyf_u_1k r_width=1u r_length=15.08u
X340 VDD_VCO.t8 a_25264_n12918.t0 VSS.t1 ppolyf_u_1k r_width=1u r_length=16u
X341 VDD_VCO.t26 a_3032_n194.t42 VDD.t78 VDD.t77 pfet_03v3 ad=1.04p pd=4.52u as=1.04p ps=4.52u w=4u l=0.28u
X342 a_15128_n19574.t2 a_3336_n12918.t5 a_9124_n19574.t0 VSS.t144 nfet_03v3 ad=4.88p pd=17.22u as=4.88p ps=17.22u w=8u l=1u
X343 a_31212_n4894.t21 VSS.t105 cap_nmos_03v3 c_width=20.4u c_length=6u
X344 VSS.t274 a_31212_n4894.t1 cap_mim_2f0_m5m6_noshield c_width=28.16u c_length=80.64u
X345 VCTRL.t5 VSS.t260 cap_nmos_03v3 c_width=27u c_length=6u
X346 VDD_VCO.t54 VSS.t250 cap_nmos_03v3 c_width=10u c_length=6u
X347 VSS.t273 a_31212_n4894.t2 cap_mim_2f0_m5m6_noshield c_width=28.16u c_length=80.64u
X348 a_31212_n14254.t0 a_34356_n14774.t0 VSS.t0 ppolyf_u_1k r_width=1u r_length=15.08u
X349 VDD_VCO.t48 a_3032_n194.t28 VDD.t132 VDD.t131 pfet_03v3 ad=1.04p pd=4.52u as=1.04p ps=4.52u w=4u l=0.28u
X350 a_31212_n4894.t121 VSS.t47 cap_nmos_03v3 c_width=20.4u c_length=6u
X351 a_31212_n4894.t155 VSS.t75 cap_nmos_03v3 c_width=20.4u c_length=6u
X352 VDD_VCO.t66 VSS.t238 cap_nmos_03v3 c_width=10u c_length=6u
X353 a_31212_n4894.t108 VSS.t11 cap_nmos_03v3 c_width=20.4u c_length=6u
X354 VDD.t128 a_3032_n194.t15 VDD_VCO.t46 VDD.t127 pfet_03v3 ad=1.04p pd=4.52u as=1.04p ps=4.52u w=4u l=0.28u
X355 a_31212_n4894.t89 VSS.t196 cap_nmos_03v3 c_width=20.4u c_length=6u
X356 VDD_VCO.t56 VSS.t248 cap_nmos_03v3 c_width=10u c_length=6u
X357 a_31212_n11134.t0 a_34356_n11654.t0 VSS.t0 ppolyf_u_1k r_width=1u r_length=15.08u
X358 a_31212_n4894.t79 VSS.t139 cap_nmos_03v3 c_width=20.4u c_length=6u
X359 a_31212_n4894.t35 VSS.t103 cap_nmos_03v3 c_width=20.4u c_length=6u
X360 a_31212_n4894.t114 VSS.t17 cap_nmos_03v3 c_width=20.4u c_length=6u
X361 a_22018_6314.t0 a_26120_7990.t0 VSS.t10 ppolyf_u_1k r_width=1u r_length=18.6u
X362 a_31212_n4894.t75 VSS.t167 cap_nmos_03v3 c_width=20.4u c_length=6u
X363 a_31212_n4894.t46 VSS.t114 cap_nmos_03v3 c_width=20.4u c_length=6u
X364 VSS.t265 a_31212_n4894.t10 cap_mim_2f0_m5m6_noshield c_width=28.16u c_length=80.64u
X365 a_31212_n4894.t126 VSS.t182 cap_nmos_03v3 c_width=20.4u c_length=6u
X366 a_31212_n4894.t191 VSS.t234 cap_nmos_03v3 c_width=20.4u c_length=6u
X367 a_22272_10590.t1 a_26120_11110.t1 VSS.t10 ppolyf_u_1k r_width=1u r_length=18.6u
X368 VDD_VCO.t16 a_3032_n194.t12 VDD.t47 VDD.t46 pfet_03v3 ad=1.04p pd=4.52u as=1.04p ps=4.52u w=4u l=0.28u
X369 a_31212_n4894.t175 VSS.t123 cap_nmos_03v3 c_width=20.4u c_length=6u
X370 a_21936_n10918.t1 a_25264_n11438.t0 VSS.t1 ppolyf_u_1k r_width=1u r_length=16u
X371 a_31212_n4894.t94 VSS.t78 cap_nmos_03v3 c_width=20.4u c_length=6u
X372 VDD_VCO.t14 a_3032_n194.t34 VDD.t43 VDD.t42 pfet_03v3 ad=1.04p pd=4.52u as=1.04p ps=4.52u w=4u l=0.28u
X373 a_31212_n4894.t172 VSS.t120 cap_nmos_03v3 c_width=20.4u c_length=6u
X374 a_20408_5436.t1 DN.t2 VSS.t220 VSS.t188 nfet_03v3 ad=0.224p pd=1.68u as=0.3304p ps=2.3u w=0.56u l=0.28u
X375 a_31212_n4894.t13 VSS.t145 cap_nmos_03v3 c_width=20.4u c_length=6u
X376 a_31212_n4894.t113 VSS.t16 cap_nmos_03v3 c_width=20.4u c_length=6u
X377 a_3336_n12398.t0 a_7700_n11878.t0 VSS.t34 ppolyf_u_1k r_width=1u r_length=21.18u
X378 a_31212_n4894.t140 VSS.t128 cap_nmos_03v3 c_width=20.4u c_length=6u
X379 a_31212_n17374.t0 a_34356_n16854.t0 VSS.t0 ppolyf_u_1k r_width=1u r_length=15.08u
X380 a_31212_n4894.t48 VSS.t116 cap_nmos_03v3 c_width=20.4u c_length=6u
X381 a_31212_n4894.t189 VSS.t232 cap_nmos_03v3 c_width=20.4u c_length=6u
X382 VDD_VCO.t51 VSS.t253 cap_nmos_03v3 c_width=10u c_length=6u
X383 a_31212_n4894.t97 VSS.t81 cap_nmos_03v3 c_width=20.4u c_length=6u
X384 VDD.t134 UPB.t4 a_16312_6176.t0 VDD.t133 pfet_03v3 ad=0.728p pd=3.54u as=0.728p ps=3.54u w=1.12u l=0.28u
X385 a_31212_n4894.t80 VSS.t140 cap_nmos_03v3 c_width=20.4u c_length=6u
X386 VDD.t122 a_3032_n194.t31 VDD_VCO.t44 VDD.t121 pfet_03v3 ad=1.04p pd=4.52u as=1.04p ps=4.52u w=4u l=0.28u
R0 VDD_VCO.n83 VDD_VCO.t8 39.2495
R1 VDD_VCO.n84 VDD_VCO.n83 24.9282
R2 VDD_VCO.n26 VDD_VCO.n20 13.5005
R3 VDD_VCO.n29 VDD_VCO.n28 13.5005
R4 VDD_VCO.n30 VDD_VCO.n18 13.5005
R5 VDD_VCO.n32 VDD_VCO.n31 13.5005
R6 VDD_VCO.n34 VDD_VCO.n16 13.5005
R7 VDD_VCO.n37 VDD_VCO.n36 13.5005
R8 VDD_VCO.n38 VDD_VCO.n14 13.5005
R9 VDD_VCO.n40 VDD_VCO.n39 13.5005
R10 VDD_VCO.n42 VDD_VCO.n12 13.5005
R11 VDD_VCO.n45 VDD_VCO.n44 13.5005
R12 VDD_VCO.n46 VDD_VCO.n10 13.5005
R13 VDD_VCO.n48 VDD_VCO.n47 13.5005
R14 VDD_VCO.n50 VDD_VCO.n8 13.5005
R15 VDD_VCO.n53 VDD_VCO.n52 13.5005
R16 VDD_VCO.n54 VDD_VCO.n6 13.5005
R17 VDD_VCO.n56 VDD_VCO.n55 13.5005
R18 VDD_VCO.n58 VDD_VCO.n4 13.5005
R19 VDD_VCO.n61 VDD_VCO.n60 13.5005
R20 VDD_VCO.n62 VDD_VCO.n2 13.5005
R21 VDD_VCO.n64 VDD_VCO.n63 13.5005
R22 VDD_VCO.n88 VDD_VCO.n87 13.5005
R23 VDD_VCO.n83 VDD_VCO.n82 10.0805
R24 VDD_VCO.n74 VDD_VCO.t66 9.7717
R25 VDD_VCO.n66 VDD_VCO.t49 9.7717
R26 VDD_VCO.n84 VDD_VCO.n0 9.0005
R27 VDD_VCO.n74 VDD_VCO.t65 8.1607
R28 VDD_VCO.n75 VDD_VCO.t64 8.1607
R29 VDD_VCO.n76 VDD_VCO.t63 8.1607
R30 VDD_VCO.n77 VDD_VCO.t62 8.1607
R31 VDD_VCO.n78 VDD_VCO.t61 8.1607
R32 VDD_VCO.n79 VDD_VCO.t60 8.1607
R33 VDD_VCO.n80 VDD_VCO.t59 8.1607
R34 VDD_VCO.n81 VDD_VCO.t58 8.1607
R35 VDD_VCO.n73 VDD_VCO.t57 8.1607
R36 VDD_VCO.n72 VDD_VCO.t56 8.1607
R37 VDD_VCO.n71 VDD_VCO.t55 8.1607
R38 VDD_VCO.n70 VDD_VCO.t54 8.1607
R39 VDD_VCO.n69 VDD_VCO.t53 8.1607
R40 VDD_VCO.n68 VDD_VCO.t52 8.1607
R41 VDD_VCO.n67 VDD_VCO.t51 8.1607
R42 VDD_VCO.n66 VDD_VCO.t50 8.1607
R43 VDD_VCO.n23 VDD_VCO.n20 6.74396
R44 VDD_VCO.n23 VDD_VCO.n22 5.75587
R45 VDD_VCO.n87 VDD_VCO.n86 5.5773
R46 VDD_VCO.n85 VDD_VCO.n65 5.5773
R47 VDD_VCO.n64 VDD_VCO.n3 5.5773
R48 VDD_VCO.n2 VDD_VCO.n1 5.5773
R49 VDD_VCO.n60 VDD_VCO.n59 5.5773
R50 VDD_VCO.n58 VDD_VCO.n57 5.5773
R51 VDD_VCO.n56 VDD_VCO.n7 5.5773
R52 VDD_VCO.n6 VDD_VCO.n5 5.5773
R53 VDD_VCO.n52 VDD_VCO.n51 5.5773
R54 VDD_VCO.n50 VDD_VCO.n49 5.5773
R55 VDD_VCO.n48 VDD_VCO.n11 5.5773
R56 VDD_VCO.n10 VDD_VCO.n9 5.5773
R57 VDD_VCO.n44 VDD_VCO.n43 5.5773
R58 VDD_VCO.n42 VDD_VCO.n41 5.5773
R59 VDD_VCO.n40 VDD_VCO.n15 5.5773
R60 VDD_VCO.n14 VDD_VCO.n13 5.5773
R61 VDD_VCO.n36 VDD_VCO.n35 5.5773
R62 VDD_VCO.n34 VDD_VCO.n33 5.5773
R63 VDD_VCO.n32 VDD_VCO.n19 5.5773
R64 VDD_VCO.n18 VDD_VCO.n17 5.5773
R65 VDD_VCO.n28 VDD_VCO.n27 5.5773
R66 VDD_VCO.n26 VDD_VCO.n25 5.5773
R67 VDD_VCO.n24 VDD_VCO.n21 5.5773
R68 VDD_VCO.n85 VDD_VCO.n84 4.5005
R69 VDD_VCO.n67 VDD_VCO.n66 1.6115
R70 VDD_VCO.n68 VDD_VCO.n67 1.6115
R71 VDD_VCO.n69 VDD_VCO.n68 1.6115
R72 VDD_VCO.n70 VDD_VCO.n69 1.6115
R73 VDD_VCO.n71 VDD_VCO.n70 1.6115
R74 VDD_VCO.n72 VDD_VCO.n71 1.6115
R75 VDD_VCO.n73 VDD_VCO.n72 1.6115
R76 VDD_VCO.n81 VDD_VCO.n80 1.6115
R77 VDD_VCO.n80 VDD_VCO.n79 1.6115
R78 VDD_VCO.n79 VDD_VCO.n78 1.6115
R79 VDD_VCO.n78 VDD_VCO.n77 1.6115
R80 VDD_VCO.n77 VDD_VCO.n76 1.6115
R81 VDD_VCO.n76 VDD_VCO.n75 1.6115
R82 VDD_VCO.n75 VDD_VCO.n74 1.6115
R83 VDD_VCO.n82 VDD_VCO.n81 0.84425
R84 VDD_VCO.n82 VDD_VCO.n73 0.76775
R85 VDD_VCO.n86 VDD_VCO.t40 0.4555
R86 VDD_VCO.n86 VDD_VCO.t28 0.4555
R87 VDD_VCO.n65 VDD_VCO.t18 0.4555
R88 VDD_VCO.n65 VDD_VCO.t15 0.4555
R89 VDD_VCO.n3 VDD_VCO.t33 0.4555
R90 VDD_VCO.n3 VDD_VCO.t17 0.4555
R91 VDD_VCO.n1 VDD_VCO.t41 0.4555
R92 VDD_VCO.n1 VDD_VCO.t24 0.4555
R93 VDD_VCO.n59 VDD_VCO.t3 0.4555
R94 VDD_VCO.n59 VDD_VCO.t4 0.4555
R95 VDD_VCO.n57 VDD_VCO.t43 0.4555
R96 VDD_VCO.n57 VDD_VCO.t34 0.4555
R97 VDD_VCO.n7 VDD_VCO.t20 0.4555
R98 VDD_VCO.n7 VDD_VCO.t26 0.4555
R99 VDD_VCO.n5 VDD_VCO.t22 0.4555
R100 VDD_VCO.n5 VDD_VCO.t27 0.4555
R101 VDD_VCO.n51 VDD_VCO.t6 0.4555
R102 VDD_VCO.n51 VDD_VCO.t39 0.4555
R103 VDD_VCO.n49 VDD_VCO.t1 0.4555
R104 VDD_VCO.n49 VDD_VCO.t2 0.4555
R105 VDD_VCO.n11 VDD_VCO.t38 0.4555
R106 VDD_VCO.n11 VDD_VCO.t14 0.4555
R107 VDD_VCO.n9 VDD_VCO.t44 0.4555
R108 VDD_VCO.n9 VDD_VCO.t35 0.4555
R109 VDD_VCO.n43 VDD_VCO.t31 0.4555
R110 VDD_VCO.n43 VDD_VCO.t37 0.4555
R111 VDD_VCO.n41 VDD_VCO.t29 0.4555
R112 VDD_VCO.n41 VDD_VCO.t48 0.4555
R113 VDD_VCO.n15 VDD_VCO.t32 0.4555
R114 VDD_VCO.n15 VDD_VCO.t21 0.4555
R115 VDD_VCO.n13 VDD_VCO.t9 0.4555
R116 VDD_VCO.n13 VDD_VCO.t5 0.4555
R117 VDD_VCO.n35 VDD_VCO.t11 0.4555
R118 VDD_VCO.n35 VDD_VCO.t36 0.4555
R119 VDD_VCO.n33 VDD_VCO.t19 0.4555
R120 VDD_VCO.n33 VDD_VCO.t42 0.4555
R121 VDD_VCO.n19 VDD_VCO.t0 0.4555
R122 VDD_VCO.n19 VDD_VCO.t30 0.4555
R123 VDD_VCO.n17 VDD_VCO.t46 0.4555
R124 VDD_VCO.n17 VDD_VCO.t23 0.4555
R125 VDD_VCO.n27 VDD_VCO.t45 0.4555
R126 VDD_VCO.n27 VDD_VCO.t25 0.4555
R127 VDD_VCO.n25 VDD_VCO.t7 0.4555
R128 VDD_VCO.n25 VDD_VCO.t16 0.4555
R129 VDD_VCO.n21 VDD_VCO.t10 0.4555
R130 VDD_VCO.n21 VDD_VCO.t47 0.4555
R131 VDD_VCO.n22 VDD_VCO.t13 0.4555
R132 VDD_VCO.n22 VDD_VCO.t12 0.4555
R133 VDD_VCO VDD_VCO.n88 0.440273
R134 VDD_VCO.n26 VDD_VCO.n24 0.3605
R135 VDD_VCO.n28 VDD_VCO.n26 0.3605
R136 VDD_VCO.n28 VDD_VCO.n18 0.3605
R137 VDD_VCO.n32 VDD_VCO.n18 0.3605
R138 VDD_VCO.n34 VDD_VCO.n32 0.3605
R139 VDD_VCO.n36 VDD_VCO.n34 0.3605
R140 VDD_VCO.n36 VDD_VCO.n14 0.3605
R141 VDD_VCO.n40 VDD_VCO.n14 0.3605
R142 VDD_VCO.n42 VDD_VCO.n40 0.3605
R143 VDD_VCO.n44 VDD_VCO.n42 0.3605
R144 VDD_VCO.n44 VDD_VCO.n10 0.3605
R145 VDD_VCO.n48 VDD_VCO.n10 0.3605
R146 VDD_VCO.n50 VDD_VCO.n48 0.3605
R147 VDD_VCO.n52 VDD_VCO.n50 0.3605
R148 VDD_VCO.n52 VDD_VCO.n6 0.3605
R149 VDD_VCO.n56 VDD_VCO.n6 0.3605
R150 VDD_VCO.n58 VDD_VCO.n56 0.3605
R151 VDD_VCO.n60 VDD_VCO.n58 0.3605
R152 VDD_VCO.n60 VDD_VCO.n2 0.3605
R153 VDD_VCO.n64 VDD_VCO.n2 0.3605
R154 VDD_VCO.n85 VDD_VCO.n64 0.3605
R155 VDD_VCO.n87 VDD_VCO.n85 0.3605
R156 VDD_VCO.n24 VDD_VCO.n23 0.178208
R157 VDD_VCO.n29 VDD_VCO.n20 0.0659545
R158 VDD_VCO.n30 VDD_VCO.n29 0.0659545
R159 VDD_VCO.n31 VDD_VCO.n30 0.0659545
R160 VDD_VCO.n31 VDD_VCO.n16 0.0659545
R161 VDD_VCO.n37 VDD_VCO.n16 0.0659545
R162 VDD_VCO.n38 VDD_VCO.n37 0.0659545
R163 VDD_VCO.n39 VDD_VCO.n38 0.0659545
R164 VDD_VCO.n39 VDD_VCO.n12 0.0659545
R165 VDD_VCO.n45 VDD_VCO.n12 0.0659545
R166 VDD_VCO.n46 VDD_VCO.n45 0.0659545
R167 VDD_VCO.n47 VDD_VCO.n46 0.0659545
R168 VDD_VCO.n47 VDD_VCO.n8 0.0659545
R169 VDD_VCO.n53 VDD_VCO.n8 0.0659545
R170 VDD_VCO.n54 VDD_VCO.n53 0.0659545
R171 VDD_VCO.n55 VDD_VCO.n54 0.0659545
R172 VDD_VCO.n55 VDD_VCO.n4 0.0659545
R173 VDD_VCO.n61 VDD_VCO.n4 0.0659545
R174 VDD_VCO.n62 VDD_VCO.n61 0.0659545
R175 VDD_VCO.n63 VDD_VCO.n62 0.0659545
R176 VDD_VCO.n63 VDD_VCO.n0 0.0659545
R177 VDD_VCO.n88 VDD_VCO.n0 0.0659545
R178 TAIL_BIAS.n3 TAIL_BIAS.t1 25.457
R179 TAIL_BIAS.n2 TAIL_BIAS.t2 22.9443
R180 TAIL_BIAS.n4 TAIL_BIAS.t0 18.3972
R181 TAIL_BIAS.n0 TAIL_BIAS.t3 12.858
R182 TAIL_BIAS.n1 TAIL_BIAS.t5 12.8512
R183 TAIL_BIAS.n0 TAIL_BIAS.t4 11.247
R184 TAIL_BIAS.n2 TAIL_BIAS.n1 10.985
R185 TAIL_BIAS TAIL_BIAS.n4 10.0299
R186 TAIL_BIAS.n3 TAIL_BIAS.n2 2.9255
R187 TAIL_BIAS.n4 TAIL_BIAS.n3 0.7655
R188 TAIL_BIAS.n1 TAIL_BIAS.n0 0.00725
R189 CP_IBIAS CP_IBIAS.n4 33.1506
R190 CP_IBIAS CP_IBIAS.t0 33
R191 CP_IBIAS.n0 CP_IBIAS.t3 16.1683
R192 CP_IBIAS.n1 CP_IBIAS.t4 15.8625
R193 CP_IBIAS.n1 CP_IBIAS.t1 15.5925
R194 CP_IBIAS.n3 CP_IBIAS.n2 6.3005
R195 CP_IBIAS.n2 CP_IBIAS.n0 6.3005
R196 CP_IBIAS.n2 CP_IBIAS.t2 2.4755
R197 CP_IBIAS.n3 CP_IBIAS.n1 0.307423
R198 CP_IBIAS.n4 CP_IBIAS.n3 0.0535769
R199 CP_IBIAS.n4 CP_IBIAS.n0 0.0535769
R200 DN DN.t2 50.3258
R201 DN.n1 DN.t3 32.2025
R202 DN DN.n1 18.0005
R203 DN.n0 DN.t1 10.9242
R204 DN.n0 DN.t0 5.50395
R205 DN.n1 DN.n0 4.98971
R206 REF_1M.n0 REF_1M.t1 44.3573
R207 REF_1M REF_1M.t2 38.5719
R208 REF_1M.n0 REF_1M.t0 31.2719
R209 REF_1M REF_1M.n0 1.55621
R210 UPB UPB.t5 67.4713
R211 UPB.n0 UPB.t4 34.4221
R212 UPB.n0 UPB.t3 27.1964
R213 UPB UPB.n3 22.5005
R214 UPB.n1 UPB.t0 11.3072
R215 UPB.n2 UPB.t2 10.8513
R216 UPB.n1 UPB.t1 5.45015
R217 UPB.n3 UPB.n2 0.485597
R218 UPB.n2 UPB.n1 0.379055
R219 UPB.n3 UPB.n0 0.0545
R220 FB_1M.n1 FB_1M.t0 40.2398
R221 FB_1M.n0 FB_1M.t2 38.5719
R222 FB_1M.n0 FB_1M.t1 32.8276
R223 FB_1M.n1 FB_1M.n0 4.5005
R224 FB_1M FB_1M.n1 0.5135
R225 VCTRL VCTRL.t3 67.907
R226 VCTRL.n2 VCTRL.n1 47.9662
R227 VCTRL.n3 VCTRL.n2 26.7305
R228 VCTRL.n3 VCTRL.t0 22.2125
R229 VCTRL.n0 VCTRL.t4 15.0184
R230 VCTRL.n2 VCTRL.n0 14.4624
R231 VCTRL.n0 VCTRL.t5 13.4074
R232 VCTRL.n1 VCTRL.t2 5.88496
R233 VCTRL VCTRL.n3 4.9055
R234 VCTRL.n1 VCTRL.t1 2.738
R235 VDD.n3 VDD.t114 1825
R236 VDD.n2 VDD.t4 1800
R237 VDD.n9 VDD.t14 1705.07
R238 VDD.n9 VDD.t135 1705.07
R239 VDD.n4 VDD.n2 690
R240 VDD.n4 VDD.n3 665
R241 VDD.n3 VDD.t133 400
R242 VDD.n2 VDD.t62 400
R243 VDD.t14 VDD.t107 384.615
R244 VDD.t135 VDD.t76 384.615
R245 VDD.n33 VDD.n32 354.611
R246 VDD.n311 VDD.n33 354.611
R247 VDD.n311 VDD.n310 354.611
R248 VDD.n309 VDD.n35 354.611
R249 VDD.n305 VDD.n35 354.611
R250 VDD.n305 VDD.n304 354.611
R251 VDD.n303 VDD.n37 354.611
R252 VDD.n38 VDD.n37 354.611
R253 VDD.n45 VDD.n38 354.611
R254 VDD.n46 VDD.n45 354.611
R255 VDD.n295 VDD.n47 354.611
R256 VDD.n295 VDD.n294 354.611
R257 VDD.n294 VDD.n293 354.611
R258 VDD.n293 VDD.n49 354.611
R259 VDD.n54 VDD.n53 354.611
R260 VDD.n287 VDD.n54 354.611
R261 VDD.n287 VDD.n286 354.611
R262 VDD.n282 VDD.n281 354.611
R263 VDD.n281 VDD.n280 354.611
R264 VDD.n280 VDD.n57 354.611
R265 VDD.n64 VDD.n63 354.611
R266 VDD.n68 VDD.n64 354.611
R267 VDD.n68 VDD.n67 354.611
R268 VDD.n304 VDD.t9 350.178
R269 VDD.n286 VDD.t52 321.81
R270 VDD.n310 VDD.t112 272.163
R271 VDD.n67 VDD.t50 257.979
R272 VDD.n282 VDD.t70 252.661
R273 VDD.t22 VDD.n57 179.965
R274 VDD.t26 VDD.t40 179.078
R275 VDD.t41 VDD.t6 179.078
R276 VDD.n63 VDD.t22 174.645
R277 VDD.n32 VDD.t64 160.462
R278 VDD.t64 VDD.t125 134.752
R279 VDD.n53 VDD.t41 132.98
R280 VDD.t50 VDD.n66 109.231
R281 VDD.n285 VDD.t70 101.951
R282 VDD.t40 VDD.n46 95.7452
R283 VDD.t36 VDD.t38 94.3401
R284 VDD.t32 VDD.t36 94.3401
R285 VDD.t129 VDD.t32 94.3401
R286 VDD.t46 VDD.t27 94.3401
R287 VDD.t123 VDD.t46 94.3401
R288 VDD.t74 VDD.t123 94.3401
R289 VDD.t68 VDD.t127 94.3401
R290 VDD.t0 VDD.t68 94.3401
R291 VDD.t85 VDD.t0 94.3401
R292 VDD.t56 VDD.t116 94.3401
R293 VDD.t116 VDD.t34 94.3401
R294 VDD.t34 VDD.t97 94.3401
R295 VDD.t20 VDD.t30 94.3401
R296 VDD.t89 VDD.t20 94.3401
R297 VDD.t60 VDD.t89 94.3401
R298 VDD.t131 VDD.t83 94.3401
R299 VDD.t87 VDD.t131 94.3401
R300 VDD.t99 VDD.t87 94.3401
R301 VDD.t121 VDD.t95 94.3401
R302 VDD.t95 VDD.t101 94.3401
R303 VDD.t101 VDD.t42 94.3401
R304 VDD.t11 VDD.t7 94.3401
R305 VDD.t24 VDD.t11 94.3401
R306 VDD.t103 VDD.t24 94.3401
R307 VDD.t79 VDD.t66 94.3401
R308 VDD.t58 VDD.t79 94.3401
R309 VDD.t77 VDD.t58 94.3401
R310 VDD.t118 VDD.t93 94.3401
R311 VDD.t93 VDD.t16 94.3401
R312 VDD.t16 VDD.t18 94.3401
R313 VDD.t72 VDD.t110 94.3401
R314 VDD.t91 VDD.t72 94.3401
R315 VDD.t48 VDD.t91 94.3401
R316 VDD.t44 VDD.t54 94.3401
R317 VDD.t108 VDD.t44 94.3401
R318 VDD.t81 VDD.t108 94.3401
R319 VDD.n18 VDD.t105 89.5005
R320 VDD.t112 VDD.n309 82.4473
R321 VDD.n47 VDD.t26 79.7877
R322 VDD.t125 VDD.n31 72.8977
R323 VDD.n259 VDD.t81 58.5911
R324 VDD.t27 VDD.n242 48.3496
R325 VDD.t127 VDD.n243 48.3496
R326 VDD.n244 VDD.t56 48.3496
R327 VDD.t30 VDD.n247 48.3496
R328 VDD.t83 VDD.n248 48.3496
R329 VDD.n249 VDD.t121 48.3496
R330 VDD.t7 VDD.n252 48.3496
R331 VDD.t66 VDD.n253 48.3496
R332 VDD.n254 VDD.t118 48.3496
R333 VDD.t110 VDD.n257 48.3496
R334 VDD.t54 VDD.n258 48.3496
R335 VDD.n242 VDD.t129 45.9911
R336 VDD.n243 VDD.t74 45.9911
R337 VDD.n244 VDD.t85 45.9911
R338 VDD.n247 VDD.t97 45.9911
R339 VDD.n248 VDD.t60 45.9911
R340 VDD.n249 VDD.t99 45.9911
R341 VDD.n252 VDD.t42 45.9911
R342 VDD.n253 VDD.t103 45.9911
R343 VDD.n254 VDD.t77 45.9911
R344 VDD.n257 VDD.t18 45.9911
R345 VDD.n258 VDD.t48 45.9911
R346 VDD.t6 VDD.n49 42.5537
R347 VDD.t105 VDD.t2 37.0005
R348 VDD.t52 VDD.n285 32.8019
R349 VDD.n8 VDD.t137 27.1631
R350 VDD.n8 VDD.t138 26.7719
R351 VDD.n10 VDD.n9 26.1005
R352 VDD.n5 VDD.n4 26.1005
R353 VDD.n74 VDD.t13 25.583
R354 VDD.n73 VDD.t29 25.583
R355 VDD.n277 VDD.n276 24.836
R356 VDD.n13 VDD.t3 19.7487
R357 VDD.n10 VDD.t136 19.2359
R358 VDD.n1 VDD.t115 19.1986
R359 VDD.n7 VDD.t5 19.1738
R360 VDD.n11 VDD.t15 18.8815
R361 VDD.n1 VDD.t134 18.8665
R362 VDD.n6 VDD.t63 18.8665
R363 VDD.n42 VDD.t10 17.6066
R364 VDD.n61 VDD.t51 17.5819
R365 VDD.n314 VDD.n30 17.5505
R366 VDD.n40 VDD.t113 17.3996
R367 VDD.n72 VDD.t23 17.2849
R368 VDD.n16 VDD.t120 16.0278
R369 VDD.n21 VDD.t106 16.0143
R370 VDD.n17 VDD.n16 15.4558
R371 VDD.n10 VDD.n8 14.93
R372 VDD.n20 VDD.n19 14.7366
R373 VDD.n75 VDD.n74 14.468
R374 VDD.n15 VDD.n14 14.0518
R375 VDD.n66 VDD.n61 13.64
R376 VDD.n71 VDD.n70 13.64
R377 VDD.n279 VDD.n278 13.64
R378 VDD.n284 VDD.n51 13.64
R379 VDD.n290 VDD.n289 13.64
R380 VDD.n292 VDD.n291 13.64
R381 VDD.n298 VDD.n297 13.64
R382 VDD.n300 VDD.n299 13.64
R383 VDD.n41 VDD.n36 13.64
R384 VDD.n308 VDD.n29 13.64
R385 VDD.n242 VDD.n241 13.3205
R386 VDD.n32 VDD.n31 12.6005
R387 VDD.n313 VDD.n33 12.6005
R388 VDD.n312 VDD.n311 12.6005
R389 VDD.n310 VDD.n34 12.6005
R390 VDD.n309 VDD.n308 12.6005
R391 VDD.n307 VDD.n35 12.6005
R392 VDD.n306 VDD.n305 12.6005
R393 VDD.n304 VDD.n36 12.6005
R394 VDD.n303 VDD.n302 12.6005
R395 VDD.n301 VDD.n37 12.6005
R396 VDD.n300 VDD.n38 12.6005
R397 VDD.n45 VDD.n39 12.6005
R398 VDD.n46 VDD.n44 12.6005
R399 VDD.n297 VDD.n47 12.6005
R400 VDD.n296 VDD.n295 12.6005
R401 VDD.n294 VDD.n48 12.6005
R402 VDD.n293 VDD.n292 12.6005
R403 VDD.n50 VDD.n49 12.6005
R404 VDD.n53 VDD.n52 12.6005
R405 VDD.n289 VDD.n54 12.6005
R406 VDD.n288 VDD.n287 12.6005
R407 VDD.n286 VDD.n55 12.6005
R408 VDD.n285 VDD.n284 12.6005
R409 VDD.n283 VDD.n282 12.6005
R410 VDD.n281 VDD.n56 12.6005
R411 VDD.n280 VDD.n279 12.6005
R412 VDD.n58 VDD.n57 12.6005
R413 VDD.n63 VDD.n62 12.6005
R414 VDD.n70 VDD.n64 12.6005
R415 VDD.n69 VDD.n68 12.6005
R416 VDD.n67 VDD.n65 12.6005
R417 VDD.n243 VDD.n241 12.6005
R418 VDD.n245 VDD.n244 12.6005
R419 VDD.n247 VDD.n246 12.6005
R420 VDD.n248 VDD.n240 12.6005
R421 VDD.n250 VDD.n249 12.6005
R422 VDD.n252 VDD.n251 12.6005
R423 VDD.n253 VDD.n239 12.6005
R424 VDD.n255 VDD.n254 12.6005
R425 VDD.n257 VDD.n256 12.6005
R426 VDD.n258 VDD.n238 12.6005
R427 VDD.n234 VDD.n233 11.2807
R428 VDD.n159 VDD.n134 11.264
R429 VDD.n161 VDD.n141 11.264
R430 VDD.n163 VDD.n147 11.264
R431 VDD.n165 VDD.n153 11.264
R432 VDD.n173 VDD.n114 11.264
R433 VDD.n205 VDD.n204 11.264
R434 VDD.n209 VDD.n113 11.264
R435 VDD.n207 VDD.n107 11.264
R436 VDD.n101 VDD.n98 11.264
R437 VDD.n230 VDD.n229 11.264
R438 VDD.n158 VDD.n130 11.264
R439 VDD.n160 VDD.n135 11.264
R440 VDD.n162 VDD.n144 11.264
R441 VDD.n164 VDD.n150 11.264
R442 VDD.n167 VDD.n166 11.264
R443 VDD.n201 VDD.n200 11.264
R444 VDD.n211 VDD.n210 11.264
R445 VDD.n208 VDD.n110 11.264
R446 VDD.n206 VDD.n104 11.264
R447 VDD.n226 VDD.n225 11.264
R448 VDD.n235 VDD.n234 11.264
R449 VDD.n157 VDD.n156 11.264
R450 VDD.n60 VDD.n59 11.174
R451 VDD.n317 VDD.n316 11.1695
R452 VDD.n43 VDD.n30 10.8005
R453 VDD.n12 VDD.n7 9.41013
R454 VDD.n22 VDD.n21 9.19737
R455 VDD.n314 VDD.n313 9.14
R456 VDD.n12 VDD.n11 9.03425
R457 VDD.n74 VDD.n73 6.7505
R458 VDD.n316 VDD.t126 6.725
R459 VDD.n59 VDD.t53 6.61536
R460 VDD VDD.n317 6.41359
R461 VDD.n59 VDD.t71 6.16086
R462 VDD.n316 VDD.t65 6.1085
R463 VDD.n187 VDD.n126 4.8365
R464 VDD.n263 VDD.n92 4.8365
R465 VDD.n28 VDD.n27 4.778
R466 VDD.n233 VDD.n232 4.54556
R467 VDD.n134 VDD.n133 4.54556
R468 VDD.n141 VDD.n140 4.54556
R469 VDD.n147 VDD.n146 4.54556
R470 VDD.n153 VDD.n152 4.54556
R471 VDD.n173 VDD.n172 4.54556
R472 VDD.n204 VDD.n203 4.54556
R473 VDD.n113 VDD.n112 4.54556
R474 VDD.n107 VDD.n106 4.54556
R475 VDD.n101 VDD.n100 4.54556
R476 VDD.n229 VDD.n228 4.54556
R477 VDD.n130 VDD.n129 4.54556
R478 VDD.n137 VDD.n135 4.54556
R479 VDD.n144 VDD.n143 4.54556
R480 VDD.n150 VDD.n149 4.54556
R481 VDD.n169 VDD.n167 4.54556
R482 VDD.n200 VDD.n199 4.54556
R483 VDD.n213 VDD.n211 4.54556
R484 VDD.n110 VDD.n109 4.54556
R485 VDD.n104 VDD.n103 4.54556
R486 VDD.n225 VDD.n224 4.54556
R487 VDD.n235 VDD.n95 4.54556
R488 VDD.n156 VDD.n155 4.54556
R489 VDD.n27 VDD.n23 4.5005
R490 VDD.n25 VDD.n23 4.5005
R491 VDD.n24 VDD.n0 4.5005
R492 VDD.n27 VDD.n26 4.5005
R493 VDD.n26 VDD.n25 4.5005
R494 VDD.n315 VDD.n314 4.5005
R495 VDD.n263 VDD.n262 4.5005
R496 VDD.n265 VDD.n264 4.5005
R497 VDD.n267 VDD.n85 4.5005
R498 VDD.n270 VDD.n269 4.5005
R499 VDD.n272 VDD.n271 4.5005
R500 VDD.n84 VDD.n81 4.5005
R501 VDD.n196 VDD.n195 4.5005
R502 VDD.n194 VDD.n193 4.5005
R503 VDD.n191 VDD.n119 4.5005
R504 VDD.n189 VDD.n188 4.5005
R505 VDD.n187 VDD.n186 4.5005
R506 VDD.n231 VDD.n97 4.5005
R507 VDD.n154 VDD.n131 4.5005
R508 VDD.n184 VDD.n183 4.5005
R509 VDD.n182 VDD.n127 4.5005
R510 VDD.n181 VDD.n138 4.5005
R511 VDD.n180 VDD.n124 4.5005
R512 VDD.n179 VDD.n123 4.5005
R513 VDD.n178 VDD.n122 4.5005
R514 VDD.n177 VDD.n121 4.5005
R515 VDD.n176 VDD.n120 4.5005
R516 VDD.n175 VDD.n170 4.5005
R517 VDD.n174 VDD.n117 4.5005
R518 VDD.n198 VDD.n115 4.5005
R519 VDD.n80 VDD.n76 4.5005
R520 VDD.n275 VDD.n274 4.5005
R521 VDD.n82 VDD.n77 4.5005
R522 VDD.n215 VDD.n214 4.5005
R523 VDD.n216 VDD.n86 4.5005
R524 VDD.n217 VDD.n87 4.5005
R525 VDD.n218 VDD.n88 4.5005
R526 VDD.n219 VDD.n89 4.5005
R527 VDD.n220 VDD.n90 4.5005
R528 VDD.n223 VDD.n221 4.5005
R529 VDD.n96 VDD.n93 4.5005
R530 VDD.n237 VDD.n236 4.5005
R531 VDD.t9 VDD.n303 4.43312
R532 VDD.n23 VDD.n22 3.10217
R533 VDD.n18 VDD.n17 2.76857
R534 VDD.n315 VDD.n29 2.7005
R535 VDD.n299 VDD.n298 2.7005
R536 VDD.n291 VDD.n290 2.7005
R537 VDD.n290 VDD.n51 2.7005
R538 VDD.n71 VDD.n61 2.7005
R539 VDD.n21 VDD.n20 2.678
R540 VDD.n41 VDD.n40 2.48675
R541 VDD.n278 VDD.n60 2.3855
R542 VDD.n291 VDD.n43 2.2505
R543 VDD.n16 VDD.n15 2.228
R544 VDD.n232 VDD.t82 1.67257
R545 VDD.n155 VDD.t39 1.67257
R546 VDD.n15 VDD.n13 1.60925
R547 VDD.n17 VDD.n14 1.60612
R548 VDD.n42 VDD.n41 1.51925
R549 VDD.n19 VDD.n14 1.51637
R550 VDD.n157 VDD.n28 1.35783
R551 VDD.n73 VDD.n30 1.283
R552 VDD.n299 VDD.n42 1.18175
R553 VDD.n19 VDD.n18 1.18058
R554 VDD.n317 VDD.n315 1.1705
R555 VDD.n278 VDD.n277 1.1705
R556 VDD.n20 VDD.n13 1.09175
R557 VDD.n80 VDD.n79 1.0773
R558 VDD.n274 VDD.n78 1.0773
R559 VDD.n72 VDD.n71 1.0355
R560 VDD.n133 VDD.n132 0.937568
R561 VDD.n140 VDD.n139 0.937568
R562 VDD.n146 VDD.n145 0.937568
R563 VDD.n152 VDD.n151 0.937568
R564 VDD.n172 VDD.n171 0.937568
R565 VDD.n203 VDD.n202 0.937568
R566 VDD.n112 VDD.n111 0.937568
R567 VDD.n106 VDD.n105 0.937568
R568 VDD.n100 VDD.n99 0.937568
R569 VDD.n228 VDD.n227 0.937568
R570 VDD.n129 VDD.n128 0.937568
R571 VDD.n137 VDD.n136 0.937568
R572 VDD.n143 VDD.n142 0.937568
R573 VDD.n149 VDD.n148 0.937568
R574 VDD.n169 VDD.n168 0.937568
R575 VDD.n199 VDD.n116 0.937568
R576 VDD.n213 VDD.n212 0.937568
R577 VDD.n109 VDD.n108 0.937568
R578 VDD.n103 VDD.n102 0.937568
R579 VDD.n224 VDD.n222 0.937568
R580 VDD.n95 VDD.n94 0.937568
R581 VDD.n313 VDD.n31 0.9005
R582 VDD.n313 VDD.n312 0.9005
R583 VDD.n312 VDD.n34 0.9005
R584 VDD.n308 VDD.n34 0.9005
R585 VDD.n308 VDD.n307 0.9005
R586 VDD.n307 VDD.n306 0.9005
R587 VDD.n306 VDD.n36 0.9005
R588 VDD.n302 VDD.n36 0.9005
R589 VDD.n302 VDD.n301 0.9005
R590 VDD.n301 VDD.n300 0.9005
R591 VDD.n300 VDD.n39 0.9005
R592 VDD.n44 VDD.n39 0.9005
R593 VDD.n297 VDD.n44 0.9005
R594 VDD.n297 VDD.n296 0.9005
R595 VDD.n296 VDD.n48 0.9005
R596 VDD.n292 VDD.n48 0.9005
R597 VDD.n292 VDD.n50 0.9005
R598 VDD.n52 VDD.n50 0.9005
R599 VDD.n289 VDD.n52 0.9005
R600 VDD.n289 VDD.n288 0.9005
R601 VDD.n288 VDD.n55 0.9005
R602 VDD.n284 VDD.n55 0.9005
R603 VDD.n284 VDD.n283 0.9005
R604 VDD.n283 VDD.n56 0.9005
R605 VDD.n279 VDD.n56 0.9005
R606 VDD.n279 VDD.n58 0.9005
R607 VDD.n62 VDD.n58 0.9005
R608 VDD.n70 VDD.n62 0.9005
R609 VDD.n70 VDD.n69 0.9005
R610 VDD.n69 VDD.n65 0.9005
R611 VDD.n66 VDD.n65 0.9005
R612 VDD.n245 VDD.n241 0.7205
R613 VDD.n246 VDD.n245 0.7205
R614 VDD.n246 VDD.n240 0.7205
R615 VDD.n250 VDD.n240 0.7205
R616 VDD.n251 VDD.n250 0.7205
R617 VDD.n251 VDD.n239 0.7205
R618 VDD.n255 VDD.n239 0.7205
R619 VDD.n256 VDD.n255 0.7205
R620 VDD.n256 VDD.n238 0.7205
R621 VDD.n259 VDD.n238 0.7205
R622 VDD.n132 VDD.t130 0.4555
R623 VDD.n132 VDD.t28 0.4555
R624 VDD.n139 VDD.t75 0.4555
R625 VDD.n139 VDD.t128 0.4555
R626 VDD.n145 VDD.t86 0.4555
R627 VDD.n145 VDD.t57 0.4555
R628 VDD.n151 VDD.t98 0.4555
R629 VDD.n151 VDD.t31 0.4555
R630 VDD.n171 VDD.t61 0.4555
R631 VDD.n171 VDD.t84 0.4555
R632 VDD.n79 VDD.t100 0.4555
R633 VDD.n79 VDD.t122 0.4555
R634 VDD.n202 VDD.t43 0.4555
R635 VDD.n202 VDD.t8 0.4555
R636 VDD.n111 VDD.t104 0.4555
R637 VDD.n111 VDD.t67 0.4555
R638 VDD.n105 VDD.t78 0.4555
R639 VDD.n105 VDD.t119 0.4555
R640 VDD.n99 VDD.t19 0.4555
R641 VDD.n99 VDD.t111 0.4555
R642 VDD.n227 VDD.t49 0.4555
R643 VDD.n227 VDD.t55 0.4555
R644 VDD.n128 VDD.t37 0.4555
R645 VDD.n128 VDD.t33 0.4555
R646 VDD.n136 VDD.t47 0.4555
R647 VDD.n136 VDD.t124 0.4555
R648 VDD.n142 VDD.t69 0.4555
R649 VDD.n142 VDD.t1 0.4555
R650 VDD.n148 VDD.t117 0.4555
R651 VDD.n148 VDD.t35 0.4555
R652 VDD.n168 VDD.t21 0.4555
R653 VDD.n168 VDD.t90 0.4555
R654 VDD.n116 VDD.t132 0.4555
R655 VDD.n116 VDD.t88 0.4555
R656 VDD.n78 VDD.t96 0.4555
R657 VDD.n78 VDD.t102 0.4555
R658 VDD.n212 VDD.t12 0.4555
R659 VDD.n212 VDD.t25 0.4555
R660 VDD.n108 VDD.t80 0.4555
R661 VDD.n108 VDD.t59 0.4555
R662 VDD.n102 VDD.t94 0.4555
R663 VDD.n102 VDD.t17 0.4555
R664 VDD.n222 VDD.t73 0.4555
R665 VDD.n222 VDD.t92 0.4555
R666 VDD.n94 VDD.t45 0.4555
R667 VDD.n94 VDD.t109 0.4555
R668 VDD.n298 VDD.n43 0.4505
R669 VDD.n183 VDD.n131 0.3965
R670 VDD.n236 VDD.n97 0.3965
R671 VDD.n22 VDD.n12 0.382151
R672 VDD.n183 VDD.n182 0.3605
R673 VDD.n182 VDD.n181 0.3605
R674 VDD.n181 VDD.n180 0.3605
R675 VDD.n180 VDD.n179 0.3605
R676 VDD.n179 VDD.n178 0.3605
R677 VDD.n178 VDD.n177 0.3605
R678 VDD.n177 VDD.n176 0.3605
R679 VDD.n176 VDD.n175 0.3605
R680 VDD.n175 VDD.n174 0.3605
R681 VDD.n174 VDD.n115 0.3605
R682 VDD.n115 VDD.n76 0.3605
R683 VDD.n275 VDD.n77 0.3605
R684 VDD.n215 VDD.n77 0.3605
R685 VDD.n216 VDD.n215 0.3605
R686 VDD.n217 VDD.n216 0.3605
R687 VDD.n218 VDD.n217 0.3605
R688 VDD.n219 VDD.n218 0.3605
R689 VDD.n220 VDD.n219 0.3605
R690 VDD.n221 VDD.n220 0.3605
R691 VDD.n221 VDD.n96 0.3605
R692 VDD.n236 VDD.n96 0.3605
R693 VDD.n11 VDD.n10 0.354875
R694 VDD.n188 VDD.n187 0.3205
R695 VDD.n188 VDD.n119 0.3205
R696 VDD.n194 VDD.n119 0.3205
R697 VDD.n195 VDD.n194 0.3205
R698 VDD.n195 VDD.n84 0.3205
R699 VDD.n271 VDD.n84 0.3205
R700 VDD.n271 VDD.n270 0.3205
R701 VDD.n270 VDD.n85 0.3205
R702 VDD.n264 VDD.n85 0.3205
R703 VDD.n264 VDD.n263 0.3205
R704 VDD.n60 VDD.n51 0.3155
R705 VDD.n75 VDD.n72 0.3155
R706 VDD.n154 VDD.n126 0.313132
R707 VDD.n186 VDD.n127 0.313132
R708 VDD.n189 VDD.n124 0.313132
R709 VDD.n191 VDD.n122 0.313132
R710 VDD.n193 VDD.n120 0.313132
R711 VDD.n196 VDD.n117 0.313132
R712 VDD.n81 VDD.n80 0.313132
R713 VDD.n272 VDD.n82 0.313132
R714 VDD.n269 VDD.n86 0.313132
R715 VDD.n267 VDD.n88 0.313132
R716 VDD.n265 VDD.n90 0.313132
R717 VDD.n262 VDD.n93 0.313132
R718 VDD.n185 VDD.n184 0.313132
R719 VDD.n138 VDD.n125 0.313132
R720 VDD.n190 VDD.n123 0.313132
R721 VDD.n192 VDD.n121 0.313132
R722 VDD.n170 VDD.n118 0.313132
R723 VDD.n198 VDD.n197 0.313132
R724 VDD.n274 VDD.n273 0.313132
R725 VDD.n214 VDD.n83 0.313132
R726 VDD.n268 VDD.n87 0.313132
R727 VDD.n266 VDD.n89 0.313132
R728 VDD.n223 VDD.n91 0.313132
R729 VDD.n261 VDD.n237 0.313132
R730 VDD.n231 VDD.n92 0.313132
R731 VDD.n276 VDD.n76 0.23225
R732 VDD.n40 VDD.n29 0.21425
R733 VDD.n277 VDD.n75 0.1805
R734 VDD.n185 VDD.n126 0.1765
R735 VDD.n186 VDD.n185 0.1605
R736 VDD.n186 VDD.n125 0.1605
R737 VDD.n189 VDD.n125 0.1605
R738 VDD.n190 VDD.n189 0.1605
R739 VDD.n191 VDD.n190 0.1605
R740 VDD.n192 VDD.n191 0.1605
R741 VDD.n193 VDD.n192 0.1605
R742 VDD.n193 VDD.n118 0.1605
R743 VDD.n196 VDD.n118 0.1605
R744 VDD.n197 VDD.n196 0.1605
R745 VDD.n197 VDD.n81 0.1605
R746 VDD.n273 VDD.n81 0.1605
R747 VDD.n273 VDD.n272 0.1605
R748 VDD.n272 VDD.n83 0.1605
R749 VDD.n269 VDD.n83 0.1605
R750 VDD.n269 VDD.n268 0.1605
R751 VDD.n268 VDD.n267 0.1605
R752 VDD.n267 VDD.n266 0.1605
R753 VDD.n266 VDD.n265 0.1605
R754 VDD.n265 VDD.n91 0.1605
R755 VDD.n262 VDD.n91 0.1605
R756 VDD.n262 VDD.n261 0.1605
R757 VDD.n261 VDD.n260 0.1595
R758 VDD.n6 VDD.n5 0.15575
R759 VDD.n5 VDD.n1 0.150125
R760 VDD.n232 VDD.n231 0.140237
R761 VDD.n155 VDD.n154 0.140237
R762 VDD.n133 VDD.n127 0.140237
R763 VDD.n140 VDD.n124 0.140237
R764 VDD.n146 VDD.n122 0.140237
R765 VDD.n152 VDD.n120 0.140237
R766 VDD.n172 VDD.n117 0.140237
R767 VDD.n203 VDD.n82 0.140237
R768 VDD.n112 VDD.n86 0.140237
R769 VDD.n106 VDD.n88 0.140237
R770 VDD.n100 VDD.n90 0.140237
R771 VDD.n228 VDD.n93 0.140237
R772 VDD.n184 VDD.n129 0.140237
R773 VDD.n138 VDD.n137 0.140237
R774 VDD.n143 VDD.n123 0.140237
R775 VDD.n149 VDD.n121 0.140237
R776 VDD.n170 VDD.n169 0.140237
R777 VDD.n199 VDD.n198 0.140237
R778 VDD.n214 VDD.n213 0.140237
R779 VDD.n109 VDD.n87 0.140237
R780 VDD.n103 VDD.n89 0.140237
R781 VDD.n224 VDD.n223 0.140237
R782 VDD.n237 VDD.n95 0.140237
R783 VDD.n276 VDD.n275 0.12875
R784 VDD.n260 VDD.n259 0.12425
R785 VDD.n205 VDD.n201 0.0462143
R786 VDD.n233 VDD.n97 0.0455609
R787 VDD.n182 VDD.n134 0.0455609
R788 VDD.n180 VDD.n141 0.0455609
R789 VDD.n178 VDD.n147 0.0455609
R790 VDD.n176 VDD.n153 0.0455609
R791 VDD.n174 VDD.n173 0.0455609
R792 VDD.n204 VDD.n77 0.0455609
R793 VDD.n216 VDD.n113 0.0455609
R794 VDD.n218 VDD.n107 0.0455609
R795 VDD.n220 VDD.n101 0.0455609
R796 VDD.n229 VDD.n96 0.0455609
R797 VDD.n183 VDD.n130 0.0455609
R798 VDD.n181 VDD.n135 0.0455609
R799 VDD.n179 VDD.n144 0.0455609
R800 VDD.n177 VDD.n150 0.0455609
R801 VDD.n175 VDD.n167 0.0455609
R802 VDD.n200 VDD.n115 0.0455609
R803 VDD.n215 VDD.n211 0.0455609
R804 VDD.n217 VDD.n110 0.0455609
R805 VDD.n219 VDD.n104 0.0455609
R806 VDD.n225 VDD.n221 0.0455609
R807 VDD.n236 VDD.n235 0.0455609
R808 VDD.n156 VDD.n131 0.0455609
R809 VDD.n25 VDD.n0 0.023
R810 VDD.n27 VDD.n0 0.023
R811 VDD.n7 VDD.n6 0.019625
R812 VDD.n260 VDD.n92 0.0175
R813 VDD.n158 VDD.n157 0.0172619
R814 VDD.n159 VDD.n158 0.0157381
R815 VDD.n160 VDD.n159 0.0157381
R816 VDD.n161 VDD.n160 0.0157381
R817 VDD.n162 VDD.n161 0.0157381
R818 VDD.n163 VDD.n162 0.0157381
R819 VDD.n164 VDD.n163 0.0157381
R820 VDD.n165 VDD.n164 0.0157381
R821 VDD.n166 VDD.n165 0.0157381
R822 VDD.n166 VDD.n114 0.0157381
R823 VDD.n201 VDD.n114 0.0157381
R824 VDD.n210 VDD.n205 0.0157381
R825 VDD.n210 VDD.n209 0.0157381
R826 VDD.n209 VDD.n208 0.0157381
R827 VDD.n208 VDD.n207 0.0157381
R828 VDD.n207 VDD.n206 0.0157381
R829 VDD.n206 VDD.n98 0.0157381
R830 VDD.n226 VDD.n98 0.0157381
R831 VDD.n230 VDD.n226 0.0157381
R832 VDD.n234 VDD.n230 0.0157381
R833 VDD VDD.n28 0.0135
R834 VDD.n24 VDD.n23 0.0105
R835 VDD.n26 VDD.n24 0.0105
R836 VSS.n1806 VSS.n10 281344
R837 VSS.n1778 VSS.n38 140124
R838 VSS.n1739 VSS.n38 112318
R839 VSS.n1664 VSS.n72 52177.6
R840 VSS.n10 VSS.t223 50196.6
R841 VSS.n1738 VSS.t32 18233.4
R842 VSS.n1811 VSS.n1810 16651.3
R843 VSS.n9 VSS.n8 16458.7
R844 VSS.n1810 VSS.t39 12296.5
R845 VSS.n1812 VSS.n1811 11786.6
R846 VSS.n1665 VSS.n1664 11410.7
R847 VSS.n1737 VSS.n1736 10058.6
R848 VSS.n1740 VSS.n1739 9059.8
R849 VSS.n1740 VSS.n10 7647.06
R850 VSS.n1732 VSS.t228 6834.66
R851 VSS.n1732 VSS.n9 5673.7
R852 VSS.n1726 VSS.n9 3924.1
R853 VSS.n1726 VSS.t39 2961.27
R854 VSS.t221 VSS.t39 2576.22
R855 VSS.t41 VSS.t221 2576.22
R856 VSS.t228 VSS.t230 2576.22
R857 VSS.t230 VSS.t84 2576.22
R858 VSS.n1751 VSS.n1740 2504.97
R859 VSS.n1739 VSS.n1738 2422.04
R860 VSS.t228 VSS.t41 2179.88
R861 VSS.n1664 VSS.t10 1799.56
R862 VSS.n38 VSS.n37 1663.56
R863 VSS.n1737 VSS.t10 1237.1
R864 VSS.n1449 VSS.n1448 902.779
R865 VSS.n1483 VSS.n1449 902.779
R866 VSS.n1483 VSS.n1482 902.779
R867 VSS.n1457 VSS.n1456 902.779
R868 VSS.n1458 VSS.n1457 902.779
R869 VSS.n1472 VSS.n1471 902.779
R870 VSS.n1471 VSS.n1460 902.779
R871 VSS.n1466 VSS.n1460 902.779
R872 VSS.n1465 VSS.n1464 902.779
R873 VSS.n1464 VSS.n1462 902.779
R874 VSS.n1800 VSS.n19 902.779
R875 VSS.n1800 VSS.n1799 902.779
R876 VSS.n1799 VSS.n1798 902.779
R877 VSS.n1795 VSS.n1794 902.779
R878 VSS.n1794 VSS.n1793 902.779
R879 VSS.n1793 VSS.n22 902.779
R880 VSS.n28 VSS.n27 902.779
R881 VSS.n1786 VSS.n28 902.779
R882 VSS.n1786 VSS.n1785 902.779
R883 VSS.n1784 VSS.n30 902.779
R884 VSS.n34 VSS.n30 902.779
R885 VSS.t228 VSS.t230 897.029
R886 VSS.t230 VSS.t84 897.029
R887 VSS.n1456 VSS.t209 889.236
R888 VSS.t262 VSS.n1465 864.41
R889 VSS.t207 VSS.n1784 855.383
R890 VSS.t223 VSS.t19 792.683
R891 VSS.n34 VSS.t158 726.736
R892 VSS.n1462 VSS.t144 717.708
R893 VSS.t58 VSS.n1458 704.168
R894 VSS.n27 VSS.t256 631.944
R895 VSS.t221 VSS.t39 620.412
R896 VSS.t41 VSS.t221 620.412
R897 VSS.t228 VSS.t230 620.412
R898 VSS.t230 VSS.t84 620.412
R899 VSS.t226 VSS.n1472 595.833
R900 VSS.n8 VSS.t188 569.269
R901 VSS.t228 VSS.t41 524.963
R902 VSS.n1798 VSS.t86 494.272
R903 VSS.n1482 VSS.t178 460.418
R904 VSS.t37 VSS.t35 455.904
R905 VSS.t178 VSS.n1481 442.361
R906 VSS.t188 VSS.t152 414.014
R907 VSS.n1795 VSS.t86 408.507
R908 VSS.n1752 VSS.n1751 372.514
R909 VSS.n1812 VSS.t20 353.158
R910 VSS.n1448 VSS.t37 331.772
R911 VSS.t256 VSS.n22 270.834
R912 VSS.t30 VSS.t226 252.779
R913 VSS.n1811 VSS.n10 213.035
R914 VSS.n1473 VSS.t58 198.612
R915 VSS.n1752 VSS.t33 196.721
R916 VSS.t144 VSS.n19 185.07
R917 VSS.n37 VSS.t158 176.042
R918 VSS.n1406 VSS.n147 173.761
R919 VSS.n1760 VSS.n48 146.572
R920 VSS.n1761 VSS.n1760 146.572
R921 VSS.n1761 VSS.n44 146.572
R922 VSS.n1766 VSS.n44 146.572
R923 VSS.n1767 VSS.n1766 146.572
R924 VSS.n1768 VSS.n1767 146.572
R925 VSS.n1773 VSS.n41 146.572
R926 VSS.n1774 VSS.n1773 146.572
R927 VSS.n1774 VSS.n33 146.572
R928 VSS.n1664 VSS.n1663 124.239
R929 VSS.t258 VSS.n1754 123.609
R930 VSS.t19 VSS.t219 118.903
R931 VSS.t35 VSS.n72 115.105
R932 VSS.t176 VSS.t20 104.993
R933 VSS.t222 VSS.n1753 88.1883
R934 VSS.t225 VSS.t176 85.9036
R935 VSS.n1811 VSS.n9 85.9036
R936 VSS.n1738 VSS.n1737 84.8323
R937 VSS.t34 VSS.n41 77.6839
R938 VSS.n1779 VSS.n33 75.7296
R939 VSS.n1779 VSS.n1778 70.8439
R940 VSS.n1768 VSS.t34 68.8896
R941 VSS.n145 VSS.n73 60.7494
R942 VSS.n1755 VSS.t222 58.3852
R943 VSS.n1473 VSS.t30 54.1672
R944 VSS.n1736 VSS.n1735 54.0341
R945 VSS.n3 VSS.t275 52.4574
R946 VSS.n1290 VSS.n202 52.1284
R947 VSS.n1285 VSS.n202 52.1284
R948 VSS.n1285 VSS.n320 52.1284
R949 VSS.n1280 VSS.n320 52.1284
R950 VSS.n1280 VSS.n469 52.1284
R951 VSS.n1275 VSS.n469 52.1284
R952 VSS.n1275 VSS.n493 52.1284
R953 VSS.n1270 VSS.n493 52.1284
R954 VSS.n1270 VSS.n517 52.1284
R955 VSS.n1265 VSS.n517 52.1284
R956 VSS.n1265 VSS.n542 52.1284
R957 VSS.n1260 VSS.n542 52.1284
R958 VSS.n1260 VSS.n567 52.1284
R959 VSS.n1256 VSS.n567 52.1284
R960 VSS.n1256 VSS.n586 52.1284
R961 VSS.n1251 VSS.n586 52.1284
R962 VSS.n1251 VSS.n606 52.1284
R963 VSS.n1246 VSS.n606 52.1284
R964 VSS.n1246 VSS.n630 52.1284
R965 VSS.n1241 VSS.n630 52.1284
R966 VSS.n1241 VSS.n654 52.1284
R967 VSS.n1236 VSS.n654 52.1284
R968 VSS.n1236 VSS.n679 52.1284
R969 VSS.n1231 VSS.n679 52.1284
R970 VSS.n1231 VSS.n704 52.1284
R971 VSS.n1227 VSS.n704 52.1284
R972 VSS.n1227 VSS.n723 52.1284
R973 VSS.n1222 VSS.n723 52.1284
R974 VSS.n1222 VSS.n743 52.1284
R975 VSS.n1217 VSS.n743 52.1284
R976 VSS.n1217 VSS.n768 52.1284
R977 VSS.n1212 VSS.n768 52.1284
R978 VSS.n1212 VSS.n792 52.1284
R979 VSS.n1207 VSS.n792 52.1284
R980 VSS.n1207 VSS.n816 52.1284
R981 VSS.n1202 VSS.n816 52.1284
R982 VSS.n1202 VSS.n841 52.1284
R983 VSS.n1198 VSS.n841 52.1284
R984 VSS.n1198 VSS.n860 52.1284
R985 VSS.n1193 VSS.n860 52.1284
R986 VSS.n1193 VSS.n880 52.1284
R987 VSS.n1188 VSS.n880 52.1284
R988 VSS.n1188 VSS.n905 52.1284
R989 VSS.n1183 VSS.n905 52.1284
R990 VSS.n1183 VSS.n929 52.1284
R991 VSS.n1178 VSS.n929 52.1284
R992 VSS.n1178 VSS.n953 52.1284
R993 VSS.n1173 VSS.n953 52.1284
R994 VSS.n1173 VSS.n978 52.1284
R995 VSS.n1169 VSS.n978 52.1284
R996 VSS.n1169 VSS.n997 52.1284
R997 VSS.n1164 VSS.n997 52.1284
R998 VSS.n1164 VSS.n1017 52.1284
R999 VSS.n1159 VSS.n1017 52.1284
R1000 VSS.n1159 VSS.n1042 52.1284
R1001 VSS.n1154 VSS.n1042 52.1284
R1002 VSS.n1154 VSS.n1066 52.1284
R1003 VSS.n1149 VSS.n1066 52.1284
R1004 VSS.n1149 VSS.n1090 52.1284
R1005 VSS.n1144 VSS.n1090 52.1284
R1006 VSS.n1144 VSS.n138 52.1284
R1007 VSS.n1406 VSS.n138 52.1284
R1008 VSS.n1753 VSS.n1752 51.7894
R1009 VSS.n1666 VSS.n1665 51.6101
R1010 VSS.n1669 VSS.n70 51.5781
R1011 VSS.n1674 VSS.n68 51.5781
R1012 VSS.n1702 VSS.n65 51.5781
R1013 VSS.n1704 VSS.n62 51.5781
R1014 VSS.n1707 VSS.n63 51.5781
R1015 VSS.n1696 VSS.n1680 51.5781
R1016 VSS.n1682 VSS.n1681 51.5781
R1017 VSS.n1692 VSS.n1689 51.5781
R1018 VSS.n1684 VSS.n1683 51.5781
R1019 VSS.n1719 VSS.n54 51.5781
R1020 VSS.n147 VSS.t0 51.4333
R1021 VSS.n1785 VSS.t207 47.3963
R1022 VSS.n55 VSS.n51 44.5168
R1023 VSS.n1689 VSS.n1684 40.5257
R1024 VSS.n1719 VSS.n1718 40.5257
R1025 VSS.n1466 VSS.t262 38.3686
R1026 VSS.n1736 VSS.n51 38.0696
R1027 VSS.n1715 VSS.t229 35.9712
R1028 VSS.n4 VSS.t224 29.3437
R1029 VSS.n1815 VSS.t21 29.319
R1030 VSS.n5 VSS.t220 29.0493
R1031 VSS.n4 VSS.t259 28.988
R1032 VSS.n1814 VSS.t177 28.9843
R1033 VSS.n1445 VSS.t85 28.9355
R1034 VSS.n1683 VSS.t156 28.8594
R1035 VSS.n6 VSS.t189 28.7092
R1036 VSS.n5 VSS.t190 28.7062
R1037 VSS.t32 VSS.t225 28.6349
R1038 VSS.n1813 VSS.n1812 28.4005
R1039 VSS.n8 VSS.n7 28.4005
R1040 VSS.n14 VSS.t40 28.3212
R1041 VSS.n1666 VSS.n69 25.1753
R1042 VSS.n1670 VSS.n1669 25.1753
R1043 VSS.n1674 VSS.n1673 25.1753
R1044 VSS.n1703 VSS.n1702 25.1753
R1045 VSS.n1708 VSS.n62 25.1753
R1046 VSS.n1679 VSS.n63 25.1753
R1047 VSS.n1696 VSS.n1695 25.1753
R1048 VSS.n1693 VSS.n1682 25.1753
R1049 VSS.n1 VSS.t157 24.341
R1050 VSS.n1754 VSS.n48 21.9864
R1051 VSS.n1808 VSS.n1807 19.8545
R1052 VSS.n1714 VSS.n57 18.5855
R1053 VSS.n25 VSS.t208 18.3449
R1054 VSS.n1790 VSS.t257 18.3359
R1055 VSS.n1780 VSS.n1779 18.3148
R1056 VSS.n304 VSS.n303 18.0981
R1057 VSS.n1661 VSS.n1660 18.0981
R1058 VSS.n342 VSS.n328 18.0005
R1059 VSS.n361 VSS.n360 18.0005
R1060 VSS.n194 VSS.n179 18.0005
R1061 VSS.n1294 VSS.n1293 18.0005
R1062 VSS.n214 VSS.n193 18.0005
R1063 VSS.n449 VSS.n448 18.0005
R1064 VSS.n1403 VSS.n1402 18.0005
R1065 VSS.n1410 VSS.n1409 18.0005
R1066 VSS.n120 VSS.n103 18.0005
R1067 VSS.n1587 VSS.n1586 18.0005
R1068 VSS.n1589 VSS.n1588 18.0005
R1069 VSS.n1625 VSS.n74 18.0005
R1070 VSS.n24 VSS.t87 17.5403
R1071 VSS.n1444 VSS.n55 16.6401
R1072 VSS.n1754 VSS.n15 16.5284
R1073 VSS.n1783 VSS.n1782 16.2455
R1074 VSS.n1789 VSS.n1788 16.2455
R1075 VSS.n1792 VSS.n1791 16.2455
R1076 VSS.n1797 VSS.n17 16.2455
R1077 VSS.n1803 VSS.n1802 16.2455
R1078 VSS.n1461 VSS.n16 16.2455
R1079 VSS.n1470 VSS.n1469 16.2455
R1080 VSS.n1476 VSS.n1475 16.2455
R1081 VSS.n1486 VSS.n1485 16.2455
R1082 VSS.n1717 VSS.n1716 15.8855
R1083 VSS.n70 VSS.n69 15.351
R1084 VSS.n1670 VSS.n68 15.351
R1085 VSS.n1673 VSS.n65 15.351
R1086 VSS.n1704 VSS.n1703 15.351
R1087 VSS.n1708 VSS.n1707 15.351
R1088 VSS.n1680 VSS.n1679 15.351
R1089 VSS.n1695 VSS.n1681 15.351
R1090 VSS.n1781 VSS.n1780 13.6805
R1091 VSS.n1805 VSS.n1804 13.6805
R1092 VSS.n1446 VSS.n1445 13.6805
R1093 VSS.n1481 VSS.t209 13.5422
R1094 VSS.n1494 VSS.n1488 12.9958
R1095 VSS.n1828 VSS.n1827 12.2214
R1096 VSS.t156 VSS.n54 11.6669
R1097 VSS.n1454 VSS.n1453 11.3855
R1098 VSS.n1488 VSS.n1487 11.3045
R1099 VSS.n1447 VSS.n72 11.3005
R1100 VSS.n1718 VSS.n1717 11.0755
R1101 VSS.n1665 VSS.n71 11.0398
R1102 VSS.n32 VSS.t159 10.8914
R1103 VSS.n147 VSS.n146 10.7605
R1104 VSS.n1671 VSS.n69 10.7605
R1105 VSS.n1694 VSS.n1693 10.7605
R1106 VSS.n1778 VSS.n1777 10.4065
R1107 VSS.n1448 VSS.n1447 10.4005
R1108 VSS.n1485 VSS.n1449 10.4005
R1109 VSS.n1484 VSS.n1483 10.4005
R1110 VSS.n1482 VSS.n1450 10.4005
R1111 VSS.n1481 VSS.n1480 10.4005
R1112 VSS.n1456 VSS.n1451 10.4005
R1113 VSS.n1457 VSS.n1455 10.4005
R1114 VSS.n1475 VSS.n1458 10.4005
R1115 VSS.n1474 VSS.n1473 10.4005
R1116 VSS.n1472 VSS.n1459 10.4005
R1117 VSS.n1471 VSS.n1470 10.4005
R1118 VSS.n1468 VSS.n1460 10.4005
R1119 VSS.n1467 VSS.n1466 10.4005
R1120 VSS.n1465 VSS.n1461 10.4005
R1121 VSS.n1464 VSS.n1463 10.4005
R1122 VSS.n1462 VSS.n18 10.4005
R1123 VSS.n1802 VSS.n19 10.4005
R1124 VSS.n1801 VSS.n1800 10.4005
R1125 VSS.n1799 VSS.n20 10.4005
R1126 VSS.n1798 VSS.n1797 10.4005
R1127 VSS.n1796 VSS.n1795 10.4005
R1128 VSS.n1794 VSS.n21 10.4005
R1129 VSS.n1793 VSS.n1792 10.4005
R1130 VSS.n23 VSS.n22 10.4005
R1131 VSS.n27 VSS.n26 10.4005
R1132 VSS.n1788 VSS.n28 10.4005
R1133 VSS.n1787 VSS.n1786 10.4005
R1134 VSS.n1785 VSS.n29 10.4005
R1135 VSS.n1784 VSS.n1783 10.4005
R1136 VSS.n31 VSS.n30 10.4005
R1137 VSS.n35 VSS.n34 10.4005
R1138 VSS.n37 VSS.n36 10.4005
R1139 VSS.n1726 VSS.n11 10.4005
R1140 VSS.n1810 VSS.n1809 10.4005
R1141 VSS.n1751 VSS.n1742 10.4005
R1142 VSS.n1753 VSS.n50 10.4005
R1143 VSS.n1756 VSS.n1755 10.4005
R1144 VSS.n1758 VSS.n48 10.4005
R1145 VSS.n1760 VSS.n1759 10.4005
R1146 VSS.n1762 VSS.n1761 10.4005
R1147 VSS.n1763 VSS.n44 10.4005
R1148 VSS.n1766 VSS.n1765 10.4005
R1149 VSS.n1767 VSS.n43 10.4005
R1150 VSS.n1769 VSS.n1768 10.4005
R1151 VSS.n1771 VSS.n41 10.4005
R1152 VSS.n1773 VSS.n1772 10.4005
R1153 VSS.n1775 VSS.n1774 10.4005
R1154 VSS.n1776 VSS.n33 10.4005
R1155 VSS.n1733 VSS.n1732 10.4005
R1156 VSS.n1667 VSS.n1666 10.4005
R1157 VSS.n1669 VSS.n1668 10.4005
R1158 VSS.n1675 VSS.n1674 10.4005
R1159 VSS.n1702 VSS.n1701 10.4005
R1160 VSS.n1699 VSS.n62 10.4005
R1161 VSS.n1698 VSS.n63 10.4005
R1162 VSS.n1697 VSS.n1696 10.4005
R1163 VSS.n1685 VSS.n1682 10.4005
R1164 VSS.n1689 VSS.n1688 10.4005
R1165 VSS.n1683 VSS.n53 10.4005
R1166 VSS.n1720 VSS.n1719 10.4005
R1167 VSS.n1722 VSS.n51 10.4005
R1168 VSS.n1735 VSS.n1734 10.4005
R1169 VSS.n71 VSS.n70 10.4005
R1170 VSS.n68 VSS.n57 10.4005
R1171 VSS.n65 VSS.n64 10.4005
R1172 VSS.n1705 VSS.n1704 10.4005
R1173 VSS.n1707 VSS.n1706 10.4005
R1174 VSS.n1680 VSS.n58 10.4005
R1175 VSS.n1690 VSS.n1681 10.4005
R1176 VSS.n1692 VSS.n1691 10.4005
R1177 VSS.n1684 VSS.n56 10.4005
R1178 VSS.n1717 VSS.n54 10.4005
R1179 VSS.n1671 VSS.n1670 10.4005
R1180 VSS.n1673 VSS.n1672 10.4005
R1181 VSS.n1703 VSS.n60 10.4005
R1182 VSS.n1709 VSS.n1708 10.4005
R1183 VSS.n1679 VSS.n61 10.4005
R1184 VSS.n1695 VSS.n1694 10.4005
R1185 VSS.n146 VSS.n145 10.4005
R1186 VSS.n1290 VSS.n1289 10.4005
R1187 VSS.n1287 VSS.n202 10.4005
R1188 VSS.n1286 VSS.n1285 10.4005
R1189 VSS.n470 VSS.n320 10.4005
R1190 VSS.n1280 VSS.n471 10.4005
R1191 VSS.n496 VSS.n469 10.4005
R1192 VSS.n1275 VSS.n497 10.4005
R1193 VSS.n519 VSS.n493 10.4005
R1194 VSS.n1270 VSS.n521 10.4005
R1195 VSS.n544 VSS.n517 10.4005
R1196 VSS.n1265 VSS.n546 10.4005
R1197 VSS.n569 VSS.n542 10.4005
R1198 VSS.n1260 VSS.n571 10.4005
R1199 VSS.n587 VSS.n567 10.4005
R1200 VSS.n1256 VSS.n588 10.4005
R1201 VSS.n609 VSS.n586 10.4005
R1202 VSS.n1251 VSS.n610 10.4005
R1203 VSS.n633 VSS.n606 10.4005
R1204 VSS.n1246 VSS.n634 10.4005
R1205 VSS.n656 VSS.n630 10.4005
R1206 VSS.n1241 VSS.n658 10.4005
R1207 VSS.n681 VSS.n654 10.4005
R1208 VSS.n1236 VSS.n683 10.4005
R1209 VSS.n706 VSS.n679 10.4005
R1210 VSS.n1231 VSS.n708 10.4005
R1211 VSS.n724 VSS.n704 10.4005
R1212 VSS.n1227 VSS.n725 10.4005
R1213 VSS.n746 VSS.n723 10.4005
R1214 VSS.n1222 VSS.n747 10.4005
R1215 VSS.n771 VSS.n743 10.4005
R1216 VSS.n1217 VSS.n772 10.4005
R1217 VSS.n795 VSS.n768 10.4005
R1218 VSS.n1212 VSS.n796 10.4005
R1219 VSS.n818 VSS.n792 10.4005
R1220 VSS.n1207 VSS.n820 10.4005
R1221 VSS.n843 VSS.n816 10.4005
R1222 VSS.n1202 VSS.n845 10.4005
R1223 VSS.n861 VSS.n841 10.4005
R1224 VSS.n1198 VSS.n862 10.4005
R1225 VSS.n883 VSS.n860 10.4005
R1226 VSS.n1193 VSS.n884 10.4005
R1227 VSS.n908 VSS.n880 10.4005
R1228 VSS.n1188 VSS.n909 10.4005
R1229 VSS.n932 VSS.n905 10.4005
R1230 VSS.n1183 VSS.n933 10.4005
R1231 VSS.n955 VSS.n929 10.4005
R1232 VSS.n1178 VSS.n957 10.4005
R1233 VSS.n980 VSS.n953 10.4005
R1234 VSS.n1173 VSS.n982 10.4005
R1235 VSS.n998 VSS.n978 10.4005
R1236 VSS.n1169 VSS.n999 10.4005
R1237 VSS.n1020 VSS.n997 10.4005
R1238 VSS.n1164 VSS.n1021 10.4005
R1239 VSS.n1045 VSS.n1017 10.4005
R1240 VSS.n1159 VSS.n1046 10.4005
R1241 VSS.n1069 VSS.n1042 10.4005
R1242 VSS.n1154 VSS.n1070 10.4005
R1243 VSS.n1092 VSS.n1066 10.4005
R1244 VSS.n1149 VSS.n1094 10.4005
R1245 VSS.n1124 VSS.n1090 10.4005
R1246 VSS.n1144 VSS.n1129 10.4005
R1247 VSS.n1128 VSS.n138 10.4005
R1248 VSS.n1406 VSS.n148 10.4005
R1249 VSS.n1290 VSS.n201 10.4005
R1250 VSS.n318 VSS.n202 10.4005
R1251 VSS.n1285 VSS.n319 10.4005
R1252 VSS.n467 VSS.n320 10.4005
R1253 VSS.n1280 VSS.n468 10.4005
R1254 VSS.n491 VSS.n469 10.4005
R1255 VSS.n1275 VSS.n492 10.4005
R1256 VSS.n514 VSS.n493 10.4005
R1257 VSS.n1270 VSS.n516 10.4005
R1258 VSS.n539 VSS.n517 10.4005
R1259 VSS.n1265 VSS.n541 10.4005
R1260 VSS.n564 VSS.n542 10.4005
R1261 VSS.n1260 VSS.n566 10.4005
R1262 VSS.n584 VSS.n567 10.4005
R1263 VSS.n1256 VSS.n585 10.4005
R1264 VSS.n604 VSS.n586 10.4005
R1265 VSS.n1251 VSS.n605 10.4005
R1266 VSS.n628 VSS.n606 10.4005
R1267 VSS.n1246 VSS.n629 10.4005
R1268 VSS.n651 VSS.n630 10.4005
R1269 VSS.n1241 VSS.n653 10.4005
R1270 VSS.n676 VSS.n654 10.4005
R1271 VSS.n1236 VSS.n678 10.4005
R1272 VSS.n701 VSS.n679 10.4005
R1273 VSS.n1231 VSS.n703 10.4005
R1274 VSS.n721 VSS.n704 10.4005
R1275 VSS.n1227 VSS.n722 10.4005
R1276 VSS.n741 VSS.n723 10.4005
R1277 VSS.n1222 VSS.n742 10.4005
R1278 VSS.n766 VSS.n743 10.4005
R1279 VSS.n1217 VSS.n767 10.4005
R1280 VSS.n790 VSS.n768 10.4005
R1281 VSS.n1212 VSS.n791 10.4005
R1282 VSS.n813 VSS.n792 10.4005
R1283 VSS.n1207 VSS.n815 10.4005
R1284 VSS.n838 VSS.n816 10.4005
R1285 VSS.n1202 VSS.n840 10.4005
R1286 VSS.n858 VSS.n841 10.4005
R1287 VSS.n1198 VSS.n859 10.4005
R1288 VSS.n878 VSS.n860 10.4005
R1289 VSS.n1193 VSS.n879 10.4005
R1290 VSS.n903 VSS.n880 10.4005
R1291 VSS.n1188 VSS.n904 10.4005
R1292 VSS.n927 VSS.n905 10.4005
R1293 VSS.n1183 VSS.n928 10.4005
R1294 VSS.n950 VSS.n929 10.4005
R1295 VSS.n1178 VSS.n952 10.4005
R1296 VSS.n975 VSS.n953 10.4005
R1297 VSS.n1173 VSS.n977 10.4005
R1298 VSS.n995 VSS.n978 10.4005
R1299 VSS.n1169 VSS.n996 10.4005
R1300 VSS.n1015 VSS.n997 10.4005
R1301 VSS.n1164 VSS.n1016 10.4005
R1302 VSS.n1040 VSS.n1017 10.4005
R1303 VSS.n1159 VSS.n1041 10.4005
R1304 VSS.n1064 VSS.n1042 10.4005
R1305 VSS.n1154 VSS.n1065 10.4005
R1306 VSS.n1087 VSS.n1066 10.4005
R1307 VSS.n1149 VSS.n1089 10.4005
R1308 VSS.n1116 VSS.n1090 10.4005
R1309 VSS.n1144 VSS.n1122 10.4005
R1310 VSS.n1121 VSS.n138 10.4005
R1311 VSS.n1406 VSS.n140 10.4005
R1312 VSS.n1291 VSS.n1290 10.4005
R1313 VSS.n321 VSS.n202 10.4005
R1314 VSS.n1285 VSS.n322 10.4005
R1315 VSS.n474 VSS.n320 10.4005
R1316 VSS.n1280 VSS.n475 10.4005
R1317 VSS.n500 VSS.n469 10.4005
R1318 VSS.n1275 VSS.n501 10.4005
R1319 VSS.n523 VSS.n493 10.4005
R1320 VSS.n1270 VSS.n525 10.4005
R1321 VSS.n548 VSS.n517 10.4005
R1322 VSS.n1265 VSS.n550 10.4005
R1323 VSS.n573 VSS.n542 10.4005
R1324 VSS.n1260 VSS.n575 10.4005
R1325 VSS.n589 VSS.n567 10.4005
R1326 VSS.n1256 VSS.n590 10.4005
R1327 VSS.n613 VSS.n586 10.4005
R1328 VSS.n1251 VSS.n614 10.4005
R1329 VSS.n637 VSS.n606 10.4005
R1330 VSS.n1246 VSS.n638 10.4005
R1331 VSS.n660 VSS.n630 10.4005
R1332 VSS.n1241 VSS.n662 10.4005
R1333 VSS.n685 VSS.n654 10.4005
R1334 VSS.n1236 VSS.n687 10.4005
R1335 VSS.n710 VSS.n679 10.4005
R1336 VSS.n1231 VSS.n712 10.4005
R1337 VSS.n726 VSS.n704 10.4005
R1338 VSS.n1227 VSS.n727 10.4005
R1339 VSS.n750 VSS.n723 10.4005
R1340 VSS.n1222 VSS.n751 10.4005
R1341 VSS.n775 VSS.n743 10.4005
R1342 VSS.n1217 VSS.n776 10.4005
R1343 VSS.n799 VSS.n768 10.4005
R1344 VSS.n1212 VSS.n800 10.4005
R1345 VSS.n822 VSS.n792 10.4005
R1346 VSS.n1207 VSS.n824 10.4005
R1347 VSS.n847 VSS.n816 10.4005
R1348 VSS.n1202 VSS.n849 10.4005
R1349 VSS.n863 VSS.n841 10.4005
R1350 VSS.n1198 VSS.n864 10.4005
R1351 VSS.n887 VSS.n860 10.4005
R1352 VSS.n1193 VSS.n888 10.4005
R1353 VSS.n912 VSS.n880 10.4005
R1354 VSS.n1188 VSS.n913 10.4005
R1355 VSS.n936 VSS.n905 10.4005
R1356 VSS.n1183 VSS.n937 10.4005
R1357 VSS.n959 VSS.n929 10.4005
R1358 VSS.n1178 VSS.n961 10.4005
R1359 VSS.n984 VSS.n953 10.4005
R1360 VSS.n1173 VSS.n986 10.4005
R1361 VSS.n1000 VSS.n978 10.4005
R1362 VSS.n1169 VSS.n1001 10.4005
R1363 VSS.n1024 VSS.n997 10.4005
R1364 VSS.n1164 VSS.n1025 10.4005
R1365 VSS.n1049 VSS.n1017 10.4005
R1366 VSS.n1159 VSS.n1050 10.4005
R1367 VSS.n1073 VSS.n1042 10.4005
R1368 VSS.n1154 VSS.n1074 10.4005
R1369 VSS.n1096 VSS.n1066 10.4005
R1370 VSS.n1149 VSS.n1098 10.4005
R1371 VSS.n1131 VSS.n1090 10.4005
R1372 VSS.n1144 VSS.n1136 10.4005
R1373 VSS.n1135 VSS.n138 10.4005
R1374 VSS.n1406 VSS.n149 10.4005
R1375 VSS.n1290 VSS.n200 10.4005
R1376 VSS.n313 VSS.n202 10.4005
R1377 VSS.n1285 VSS.n314 10.4005
R1378 VSS.n463 VSS.n320 10.4005
R1379 VSS.n1280 VSS.n464 10.4005
R1380 VSS.n487 VSS.n469 10.4005
R1381 VSS.n1275 VSS.n488 10.4005
R1382 VSS.n510 VSS.n493 10.4005
R1383 VSS.n1270 VSS.n512 10.4005
R1384 VSS.n535 VSS.n517 10.4005
R1385 VSS.n1265 VSS.n537 10.4005
R1386 VSS.n560 VSS.n542 10.4005
R1387 VSS.n1260 VSS.n562 10.4005
R1388 VSS.n582 VSS.n567 10.4005
R1389 VSS.n1256 VSS.n583 10.4005
R1390 VSS.n600 VSS.n586 10.4005
R1391 VSS.n1251 VSS.n601 10.4005
R1392 VSS.n624 VSS.n606 10.4005
R1393 VSS.n1246 VSS.n625 10.4005
R1394 VSS.n647 VSS.n630 10.4005
R1395 VSS.n1241 VSS.n649 10.4005
R1396 VSS.n672 VSS.n654 10.4005
R1397 VSS.n1236 VSS.n674 10.4005
R1398 VSS.n697 VSS.n679 10.4005
R1399 VSS.n1231 VSS.n699 10.4005
R1400 VSS.n719 VSS.n704 10.4005
R1401 VSS.n1227 VSS.n720 10.4005
R1402 VSS.n737 VSS.n723 10.4005
R1403 VSS.n1222 VSS.n738 10.4005
R1404 VSS.n762 VSS.n743 10.4005
R1405 VSS.n1217 VSS.n763 10.4005
R1406 VSS.n786 VSS.n768 10.4005
R1407 VSS.n1212 VSS.n787 10.4005
R1408 VSS.n809 VSS.n792 10.4005
R1409 VSS.n1207 VSS.n811 10.4005
R1410 VSS.n834 VSS.n816 10.4005
R1411 VSS.n1202 VSS.n836 10.4005
R1412 VSS.n856 VSS.n841 10.4005
R1413 VSS.n1198 VSS.n857 10.4005
R1414 VSS.n874 VSS.n860 10.4005
R1415 VSS.n1193 VSS.n875 10.4005
R1416 VSS.n899 VSS.n880 10.4005
R1417 VSS.n1188 VSS.n900 10.4005
R1418 VSS.n923 VSS.n905 10.4005
R1419 VSS.n1183 VSS.n924 10.4005
R1420 VSS.n946 VSS.n929 10.4005
R1421 VSS.n1178 VSS.n948 10.4005
R1422 VSS.n971 VSS.n953 10.4005
R1423 VSS.n1173 VSS.n973 10.4005
R1424 VSS.n993 VSS.n978 10.4005
R1425 VSS.n1169 VSS.n994 10.4005
R1426 VSS.n1011 VSS.n997 10.4005
R1427 VSS.n1164 VSS.n1012 10.4005
R1428 VSS.n1036 VSS.n1017 10.4005
R1429 VSS.n1159 VSS.n1037 10.4005
R1430 VSS.n1060 VSS.n1042 10.4005
R1431 VSS.n1154 VSS.n1061 10.4005
R1432 VSS.n1083 VSS.n1066 10.4005
R1433 VSS.n1149 VSS.n1085 10.4005
R1434 VSS.n1109 VSS.n1090 10.4005
R1435 VSS.n1144 VSS.n1114 10.4005
R1436 VSS.n1113 VSS.n138 10.4005
R1437 VSS.n1406 VSS.n139 10.4005
R1438 VSS.n1290 VSS.n199 10.4005
R1439 VSS.n356 VSS.n202 10.4005
R1440 VSS.n1285 VSS.n323 10.4005
R1441 VSS.n478 VSS.n320 10.4005
R1442 VSS.n1280 VSS.n1279 10.4005
R1443 VSS.n1277 VSS.n469 10.4005
R1444 VSS.n1276 VSS.n1275 10.4005
R1445 VSS.n493 VSS.n480 10.4005
R1446 VSS.n1270 VSS.n1269 10.4005
R1447 VSS.n1268 VSS.n517 10.4005
R1448 VSS.n1266 VSS.n1265 10.4005
R1449 VSS.n542 VSS.n529 10.4005
R1450 VSS.n1260 VSS.n1259 10.4005
R1451 VSS.n1258 VSS.n567 10.4005
R1452 VSS.n1257 VSS.n1256 10.4005
R1453 VSS.n615 VSS.n586 10.4005
R1454 VSS.n1251 VSS.n1250 10.4005
R1455 VSS.n1248 VSS.n606 10.4005
R1456 VSS.n1247 VSS.n1246 10.4005
R1457 VSS.n630 VSS.n617 10.4005
R1458 VSS.n1241 VSS.n1240 10.4005
R1459 VSS.n1239 VSS.n654 10.4005
R1460 VSS.n1237 VSS.n1236 10.4005
R1461 VSS.n679 VSS.n666 10.4005
R1462 VSS.n1231 VSS.n1230 10.4005
R1463 VSS.n1229 VSS.n704 10.4005
R1464 VSS.n1228 VSS.n1227 10.4005
R1465 VSS.n752 VSS.n723 10.4005
R1466 VSS.n1222 VSS.n1221 10.4005
R1467 VSS.n1219 VSS.n743 10.4005
R1468 VSS.n1218 VSS.n1217 10.4005
R1469 VSS.n801 VSS.n768 10.4005
R1470 VSS.n1212 VSS.n1211 10.4005
R1471 VSS.n1210 VSS.n792 10.4005
R1472 VSS.n1208 VSS.n1207 10.4005
R1473 VSS.n816 VSS.n803 10.4005
R1474 VSS.n1202 VSS.n1201 10.4005
R1475 VSS.n1200 VSS.n841 10.4005
R1476 VSS.n1199 VSS.n1198 10.4005
R1477 VSS.n889 VSS.n860 10.4005
R1478 VSS.n1193 VSS.n1192 10.4005
R1479 VSS.n1190 VSS.n880 10.4005
R1480 VSS.n1189 VSS.n1188 10.4005
R1481 VSS.n938 VSS.n905 10.4005
R1482 VSS.n1183 VSS.n1182 10.4005
R1483 VSS.n1181 VSS.n929 10.4005
R1484 VSS.n1179 VSS.n1178 10.4005
R1485 VSS.n953 VSS.n940 10.4005
R1486 VSS.n1173 VSS.n1172 10.4005
R1487 VSS.n1171 VSS.n978 10.4005
R1488 VSS.n1170 VSS.n1169 10.4005
R1489 VSS.n1026 VSS.n997 10.4005
R1490 VSS.n1164 VSS.n1163 10.4005
R1491 VSS.n1161 VSS.n1017 10.4005
R1492 VSS.n1160 VSS.n1159 10.4005
R1493 VSS.n1075 VSS.n1042 10.4005
R1494 VSS.n1154 VSS.n1153 10.4005
R1495 VSS.n1152 VSS.n1066 10.4005
R1496 VSS.n1150 VSS.n1149 10.4005
R1497 VSS.n1090 VSS.n1077 10.4005
R1498 VSS.n1144 VSS.n1143 10.4005
R1499 VSS.n1142 VSS.n138 10.4005
R1500 VSS.n1406 VSS.n150 10.4005
R1501 VSS.n1290 VSS.n198 10.4005
R1502 VSS.n324 VSS.n202 10.4005
R1503 VSS.n1285 VSS.n309 10.4005
R1504 VSS.n459 VSS.n320 10.4005
R1505 VSS.n1280 VSS.n460 10.4005
R1506 VSS.n483 VSS.n469 10.4005
R1507 VSS.n1275 VSS.n484 10.4005
R1508 VSS.n506 VSS.n493 10.4005
R1509 VSS.n1270 VSS.n508 10.4005
R1510 VSS.n531 VSS.n517 10.4005
R1511 VSS.n1265 VSS.n533 10.4005
R1512 VSS.n556 VSS.n542 10.4005
R1513 VSS.n1260 VSS.n558 10.4005
R1514 VSS.n580 VSS.n567 10.4005
R1515 VSS.n1256 VSS.n581 10.4005
R1516 VSS.n596 VSS.n586 10.4005
R1517 VSS.n1251 VSS.n597 10.4005
R1518 VSS.n620 VSS.n606 10.4005
R1519 VSS.n1246 VSS.n621 10.4005
R1520 VSS.n643 VSS.n630 10.4005
R1521 VSS.n1241 VSS.n645 10.4005
R1522 VSS.n668 VSS.n654 10.4005
R1523 VSS.n1236 VSS.n670 10.4005
R1524 VSS.n693 VSS.n679 10.4005
R1525 VSS.n1231 VSS.n695 10.4005
R1526 VSS.n717 VSS.n704 10.4005
R1527 VSS.n1227 VSS.n718 10.4005
R1528 VSS.n733 VSS.n723 10.4005
R1529 VSS.n1222 VSS.n734 10.4005
R1530 VSS.n758 VSS.n743 10.4005
R1531 VSS.n1217 VSS.n759 10.4005
R1532 VSS.n782 VSS.n768 10.4005
R1533 VSS.n1212 VSS.n783 10.4005
R1534 VSS.n805 VSS.n792 10.4005
R1535 VSS.n1207 VSS.n807 10.4005
R1536 VSS.n830 VSS.n816 10.4005
R1537 VSS.n1202 VSS.n832 10.4005
R1538 VSS.n854 VSS.n841 10.4005
R1539 VSS.n1198 VSS.n855 10.4005
R1540 VSS.n870 VSS.n860 10.4005
R1541 VSS.n1193 VSS.n871 10.4005
R1542 VSS.n895 VSS.n880 10.4005
R1543 VSS.n1188 VSS.n896 10.4005
R1544 VSS.n919 VSS.n905 10.4005
R1545 VSS.n1183 VSS.n920 10.4005
R1546 VSS.n942 VSS.n929 10.4005
R1547 VSS.n1178 VSS.n944 10.4005
R1548 VSS.n967 VSS.n953 10.4005
R1549 VSS.n1173 VSS.n969 10.4005
R1550 VSS.n991 VSS.n978 10.4005
R1551 VSS.n1169 VSS.n992 10.4005
R1552 VSS.n1007 VSS.n997 10.4005
R1553 VSS.n1164 VSS.n1008 10.4005
R1554 VSS.n1032 VSS.n1017 10.4005
R1555 VSS.n1159 VSS.n1033 10.4005
R1556 VSS.n1056 VSS.n1042 10.4005
R1557 VSS.n1154 VSS.n1057 10.4005
R1558 VSS.n1079 VSS.n1066 10.4005
R1559 VSS.n1149 VSS.n1081 10.4005
R1560 VSS.n1104 VSS.n1090 10.4005
R1561 VSS.n1144 VSS.n1107 10.4005
R1562 VSS.n1106 VSS.n138 10.4005
R1563 VSS.n1407 VSS.n1406 10.4005
R1564 VSS.n1290 VSS.n197 10.4005
R1565 VSS.n453 VSS.n202 10.4005
R1566 VSS.n1285 VSS.n1284 10.4005
R1567 VSS.n1282 VSS.n320 10.4005
R1568 VSS.n1281 VSS.n1280 10.4005
R1569 VSS.n502 VSS.n469 10.4005
R1570 VSS.n1275 VSS.n1274 10.4005
R1571 VSS.n1273 VSS.n493 10.4005
R1572 VSS.n1271 VSS.n1270 10.4005
R1573 VSS.n517 VSS.n504 10.4005
R1574 VSS.n1265 VSS.n1264 10.4005
R1575 VSS.n1263 VSS.n542 10.4005
R1576 VSS.n1261 VSS.n1260 10.4005
R1577 VSS.n567 VSS.n554 10.4005
R1578 VSS.n1256 VSS.n1255 10.4005
R1579 VSS.n1253 VSS.n586 10.4005
R1580 VSS.n1252 VSS.n1251 10.4005
R1581 VSS.n639 VSS.n606 10.4005
R1582 VSS.n1246 VSS.n1245 10.4005
R1583 VSS.n1244 VSS.n630 10.4005
R1584 VSS.n1242 VSS.n1241 10.4005
R1585 VSS.n654 VSS.n641 10.4005
R1586 VSS.n1236 VSS.n1235 10.4005
R1587 VSS.n1234 VSS.n679 10.4005
R1588 VSS.n1232 VSS.n1231 10.4005
R1589 VSS.n704 VSS.n691 10.4005
R1590 VSS.n1227 VSS.n1226 10.4005
R1591 VSS.n1224 VSS.n723 10.4005
R1592 VSS.n1223 VSS.n1222 10.4005
R1593 VSS.n777 VSS.n743 10.4005
R1594 VSS.n1217 VSS.n1216 10.4005
R1595 VSS.n1214 VSS.n768 10.4005
R1596 VSS.n1213 VSS.n1212 10.4005
R1597 VSS.n792 VSS.n779 10.4005
R1598 VSS.n1207 VSS.n1206 10.4005
R1599 VSS.n1205 VSS.n816 10.4005
R1600 VSS.n1203 VSS.n1202 10.4005
R1601 VSS.n841 VSS.n828 10.4005
R1602 VSS.n1198 VSS.n1197 10.4005
R1603 VSS.n1195 VSS.n860 10.4005
R1604 VSS.n1194 VSS.n1193 10.4005
R1605 VSS.n914 VSS.n880 10.4005
R1606 VSS.n1188 VSS.n1187 10.4005
R1607 VSS.n1185 VSS.n905 10.4005
R1608 VSS.n1184 VSS.n1183 10.4005
R1609 VSS.n929 VSS.n916 10.4005
R1610 VSS.n1178 VSS.n1177 10.4005
R1611 VSS.n1176 VSS.n953 10.4005
R1612 VSS.n1174 VSS.n1173 10.4005
R1613 VSS.n978 VSS.n965 10.4005
R1614 VSS.n1169 VSS.n1168 10.4005
R1615 VSS.n1166 VSS.n997 10.4005
R1616 VSS.n1165 VSS.n1164 10.4005
R1617 VSS.n1051 VSS.n1017 10.4005
R1618 VSS.n1159 VSS.n1158 10.4005
R1619 VSS.n1156 VSS.n1042 10.4005
R1620 VSS.n1155 VSS.n1154 10.4005
R1621 VSS.n1066 VSS.n1053 10.4005
R1622 VSS.n1149 VSS.n1148 10.4005
R1623 VSS.n1147 VSS.n1090 10.4005
R1624 VSS.n1145 VSS.n1144 10.4005
R1625 VSS.n1102 VSS.n138 10.4005
R1626 VSS.n1406 VSS.n1405 10.4005
R1627 VSS.n1663 VSS.n73 10.0881
R1628 VSS.t1 VSS.n1692 9.8248
R1629 VSS.n1713 VSS.n58 9.5765
R1630 VSS.n36 VSS.n32 9.446
R1631 VSS.n1480 VSS.n1479 9.4415
R1632 VSS VSS.n1 9.06238
R1633 VSS.n1781 VSS.n32 9.05
R1634 VSS.n1713 VSS.n1712 9.0005
R1635 VSS.n1822 VSS.n1821 7.29771
R1636 VSS.n1718 VSS.n55 7.06171
R1637 VSS.n1663 VSS.n1662 6.8541
R1638 VSS.n1487 VSS.t36 6.84275
R1639 VSS.n1479 VSS.n1477 6.8045
R1640 VSS.n1478 VSS.t179 6.7685
R1641 VSS.n1805 VSS.n15 6.37925
R1642 VSS.n1478 VSS.t210 6.341
R1643 VSS.n1714 VSS.n1713 6.3095
R1644 VSS.n1487 VSS.t38 6.26675
R1645 VSS.n1453 VSS.n1452 6.24686
R1646 VSS.n1453 VSS.t227 6.02636
R1647 VSS.n1829 VSS.n3 6.02245
R1648 VSS.n1693 VSS.t1 5.52667
R1649 VSS.n1780 VSS.n15 5.27675
R1650 VSS.n1751 VSS.n1741 5.16271
R1651 VSS.n1751 VSS.n1745 5.16271
R1652 VSS.n1732 VSS.n1731 5.16271
R1653 VSS.n1735 VSS.n9 4.91265
R1654 VSS.n1828 VSS.n1815 4.5255
R1655 VSS.n1479 VSS.n1478 4.5005
R1656 VSS.n1821 VSS.n1817 4.5005
R1657 VSS.n1819 VSS.n1817 4.5005
R1658 VSS.n1818 VSS.n1816 4.5005
R1659 VSS.n1821 VSS.n1820 4.5005
R1660 VSS.n1820 VSS.n1819 4.5005
R1661 VSS.n1827 VSS.n1822 4.5005
R1662 VSS.n1827 VSS.n1826 4.5005
R1663 VSS.n1824 VSS.n1823 4.5005
R1664 VSS.n1825 VSS.n1822 4.5005
R1665 VSS.n1826 VSS.n1825 4.5005
R1666 VSS.n447 VSS.n446 4.5005
R1667 VSS.n445 VSS.n330 4.5005
R1668 VSS.n444 VSS.n443 4.5005
R1669 VSS.n442 VSS.n331 4.5005
R1670 VSS.n441 VSS.n440 4.5005
R1671 VSS.n439 VSS.n332 4.5005
R1672 VSS.n438 VSS.n437 4.5005
R1673 VSS.n436 VSS.n333 4.5005
R1674 VSS.n435 VSS.n434 4.5005
R1675 VSS.n433 VSS.n334 4.5005
R1676 VSS.n432 VSS.n431 4.5005
R1677 VSS.n430 VSS.n335 4.5005
R1678 VSS.n429 VSS.n428 4.5005
R1679 VSS.n427 VSS.n336 4.5005
R1680 VSS.n426 VSS.n425 4.5005
R1681 VSS.n424 VSS.n337 4.5005
R1682 VSS.n423 VSS.n422 4.5005
R1683 VSS.n421 VSS.n338 4.5005
R1684 VSS.n420 VSS.n419 4.5005
R1685 VSS.n418 VSS.n417 4.5005
R1686 VSS.n416 VSS.n340 4.5005
R1687 VSS.n415 VSS.n414 4.5005
R1688 VSS.n413 VSS.n341 4.5005
R1689 VSS.n412 VSS.n411 4.5005
R1690 VSS.n410 VSS.n409 4.5005
R1691 VSS.n408 VSS.n343 4.5005
R1692 VSS.n407 VSS.n406 4.5005
R1693 VSS.n405 VSS.n344 4.5005
R1694 VSS.n404 VSS.n403 4.5005
R1695 VSS.n402 VSS.n345 4.5005
R1696 VSS.n401 VSS.n400 4.5005
R1697 VSS.n399 VSS.n346 4.5005
R1698 VSS.n398 VSS.n397 4.5005
R1699 VSS.n396 VSS.n347 4.5005
R1700 VSS.n395 VSS.n394 4.5005
R1701 VSS.n393 VSS.n348 4.5005
R1702 VSS.n392 VSS.n391 4.5005
R1703 VSS.n390 VSS.n349 4.5005
R1704 VSS.n389 VSS.n388 4.5005
R1705 VSS.n387 VSS.n350 4.5005
R1706 VSS.n386 VSS.n385 4.5005
R1707 VSS.n384 VSS.n351 4.5005
R1708 VSS.n383 VSS.n382 4.5005
R1709 VSS.n381 VSS.n352 4.5005
R1710 VSS.n380 VSS.n379 4.5005
R1711 VSS.n378 VSS.n353 4.5005
R1712 VSS.n377 VSS.n376 4.5005
R1713 VSS.n375 VSS.n354 4.5005
R1714 VSS.n374 VSS.n373 4.5005
R1715 VSS.n372 VSS.n355 4.5005
R1716 VSS.n371 VSS.n370 4.5005
R1717 VSS.n369 VSS.n362 4.5005
R1718 VSS.n368 VSS.n367 4.5005
R1719 VSS.n366 VSS.n363 4.5005
R1720 VSS.n365 VSS.n364 4.5005
R1721 VSS.n169 VSS.n167 4.5005
R1722 VSS.n1357 VSS.n1356 4.5005
R1723 VSS.n1355 VSS.n168 4.5005
R1724 VSS.n1354 VSS.n1353 4.5005
R1725 VSS.n1352 VSS.n170 4.5005
R1726 VSS.n1351 VSS.n1350 4.5005
R1727 VSS.n1349 VSS.n171 4.5005
R1728 VSS.n1348 VSS.n1347 4.5005
R1729 VSS.n1346 VSS.n172 4.5005
R1730 VSS.n1345 VSS.n1344 4.5005
R1731 VSS.n1343 VSS.n173 4.5005
R1732 VSS.n1342 VSS.n1341 4.5005
R1733 VSS.n1339 VSS.n174 4.5005
R1734 VSS.n1338 VSS.n1337 4.5005
R1735 VSS.n1336 VSS.n176 4.5005
R1736 VSS.n1335 VSS.n1334 4.5005
R1737 VSS.n1333 VSS.n177 4.5005
R1738 VSS.n1332 VSS.n1331 4.5005
R1739 VSS.n1330 VSS.n178 4.5005
R1740 VSS.n1329 VSS.n1328 4.5005
R1741 VSS.n1327 VSS.n180 4.5005
R1742 VSS.n1326 VSS.n1325 4.5005
R1743 VSS.n1324 VSS.n181 4.5005
R1744 VSS.n1323 VSS.n1322 4.5005
R1745 VSS.n1321 VSS.n182 4.5005
R1746 VSS.n1320 VSS.n1319 4.5005
R1747 VSS.n1318 VSS.n183 4.5005
R1748 VSS.n1317 VSS.n1316 4.5005
R1749 VSS.n1315 VSS.n184 4.5005
R1750 VSS.n1314 VSS.n1313 4.5005
R1751 VSS.n1312 VSS.n185 4.5005
R1752 VSS.n1311 VSS.n1310 4.5005
R1753 VSS.n1309 VSS.n186 4.5005
R1754 VSS.n1308 VSS.n1307 4.5005
R1755 VSS.n1306 VSS.n187 4.5005
R1756 VSS.n1305 VSS.n1304 4.5005
R1757 VSS.n1303 VSS.n188 4.5005
R1758 VSS.n1302 VSS.n1301 4.5005
R1759 VSS.n1300 VSS.n189 4.5005
R1760 VSS.n1299 VSS.n1298 4.5005
R1761 VSS.n1297 VSS.n190 4.5005
R1762 VSS.n1296 VSS.n1295 4.5005
R1763 VSS.n192 VSS.n191 4.5005
R1764 VSS.n236 VSS.n235 4.5005
R1765 VSS.n238 VSS.n237 4.5005
R1766 VSS.n239 VSS.n234 4.5005
R1767 VSS.n241 VSS.n240 4.5005
R1768 VSS.n242 VSS.n233 4.5005
R1769 VSS.n244 VSS.n243 4.5005
R1770 VSS.n246 VSS.n245 4.5005
R1771 VSS.n247 VSS.n222 4.5005
R1772 VSS.n249 VSS.n248 4.5005
R1773 VSS.n250 VSS.n221 4.5005
R1774 VSS.n252 VSS.n251 4.5005
R1775 VSS.n253 VSS.n220 4.5005
R1776 VSS.n255 VSS.n254 4.5005
R1777 VSS.n256 VSS.n219 4.5005
R1778 VSS.n258 VSS.n257 4.5005
R1779 VSS.n259 VSS.n218 4.5005
R1780 VSS.n261 VSS.n260 4.5005
R1781 VSS.n262 VSS.n217 4.5005
R1782 VSS.n264 VSS.n263 4.5005
R1783 VSS.n265 VSS.n216 4.5005
R1784 VSS.n267 VSS.n266 4.5005
R1785 VSS.n268 VSS.n215 4.5005
R1786 VSS.n270 VSS.n269 4.5005
R1787 VSS.n272 VSS.n271 4.5005
R1788 VSS.n273 VSS.n213 4.5005
R1789 VSS.n275 VSS.n274 4.5005
R1790 VSS.n276 VSS.n212 4.5005
R1791 VSS.n278 VSS.n277 4.5005
R1792 VSS.n279 VSS.n211 4.5005
R1793 VSS.n281 VSS.n280 4.5005
R1794 VSS.n282 VSS.n210 4.5005
R1795 VSS.n284 VSS.n283 4.5005
R1796 VSS.n285 VSS.n209 4.5005
R1797 VSS.n287 VSS.n286 4.5005
R1798 VSS.n288 VSS.n208 4.5005
R1799 VSS.n290 VSS.n289 4.5005
R1800 VSS.n291 VSS.n207 4.5005
R1801 VSS.n293 VSS.n292 4.5005
R1802 VSS.n294 VSS.n206 4.5005
R1803 VSS.n296 VSS.n295 4.5005
R1804 VSS.n297 VSS.n205 4.5005
R1805 VSS.n299 VSS.n298 4.5005
R1806 VSS.n300 VSS.n204 4.5005
R1807 VSS.n302 VSS.n301 4.5005
R1808 VSS.n1527 VSS.n1526 4.5005
R1809 VSS.n1528 VSS.n110 4.5005
R1810 VSS.n1530 VSS.n1529 4.5005
R1811 VSS.n1532 VSS.n108 4.5005
R1812 VSS.n1534 VSS.n1533 4.5005
R1813 VSS.n1535 VSS.n107 4.5005
R1814 VSS.n1537 VSS.n1536 4.5005
R1815 VSS.n1538 VSS.n105 4.5005
R1816 VSS.n1585 VSS.n1584 4.5005
R1817 VSS.n1583 VSS.n106 4.5005
R1818 VSS.n1582 VSS.n1581 4.5005
R1819 VSS.n1580 VSS.n1539 4.5005
R1820 VSS.n1579 VSS.n1578 4.5005
R1821 VSS.n1577 VSS.n1540 4.5005
R1822 VSS.n1576 VSS.n1575 4.5005
R1823 VSS.n1574 VSS.n1541 4.5005
R1824 VSS.n1573 VSS.n1572 4.5005
R1825 VSS.n1571 VSS.n1542 4.5005
R1826 VSS.n1570 VSS.n1569 4.5005
R1827 VSS.n1568 VSS.n1543 4.5005
R1828 VSS.n1567 VSS.n1566 4.5005
R1829 VSS.n1565 VSS.n1544 4.5005
R1830 VSS.n1564 VSS.n1563 4.5005
R1831 VSS.n1562 VSS.n1545 4.5005
R1832 VSS.n1561 VSS.n1560 4.5005
R1833 VSS.n1559 VSS.n1546 4.5005
R1834 VSS.n1558 VSS.n1557 4.5005
R1835 VSS.n1556 VSS.n1547 4.5005
R1836 VSS.n1555 VSS.n1554 4.5005
R1837 VSS.n1553 VSS.n1548 4.5005
R1838 VSS.n1552 VSS.n1551 4.5005
R1839 VSS.n1550 VSS.n1549 4.5005
R1840 VSS.n101 VSS.n100 4.5005
R1841 VSS.n1591 VSS.n1590 4.5005
R1842 VSS.n1592 VSS.n99 4.5005
R1843 VSS.n1594 VSS.n1593 4.5005
R1844 VSS.n1595 VSS.n98 4.5005
R1845 VSS.n1597 VSS.n1596 4.5005
R1846 VSS.n1598 VSS.n97 4.5005
R1847 VSS.n1600 VSS.n1599 4.5005
R1848 VSS.n1602 VSS.n1601 4.5005
R1849 VSS.n1603 VSS.n95 4.5005
R1850 VSS.n1605 VSS.n1604 4.5005
R1851 VSS.n1606 VSS.n94 4.5005
R1852 VSS.n1608 VSS.n1607 4.5005
R1853 VSS.n1609 VSS.n93 4.5005
R1854 VSS.n1611 VSS.n1610 4.5005
R1855 VSS.n1612 VSS.n92 4.5005
R1856 VSS.n1614 VSS.n1613 4.5005
R1857 VSS.n1615 VSS.n91 4.5005
R1858 VSS.n1617 VSS.n1616 4.5005
R1859 VSS.n1618 VSS.n90 4.5005
R1860 VSS.n1620 VSS.n1619 4.5005
R1861 VSS.n1621 VSS.n89 4.5005
R1862 VSS.n1623 VSS.n1622 4.5005
R1863 VSS.n1624 VSS.n88 4.5005
R1864 VSS.n1627 VSS.n1626 4.5005
R1865 VSS.n1628 VSS.n87 4.5005
R1866 VSS.n1630 VSS.n1629 4.5005
R1867 VSS.n1631 VSS.n86 4.5005
R1868 VSS.n1633 VSS.n1632 4.5005
R1869 VSS.n1634 VSS.n85 4.5005
R1870 VSS.n1636 VSS.n1635 4.5005
R1871 VSS.n1637 VSS.n84 4.5005
R1872 VSS.n1639 VSS.n1638 4.5005
R1873 VSS.n1640 VSS.n83 4.5005
R1874 VSS.n1642 VSS.n1641 4.5005
R1875 VSS.n1643 VSS.n82 4.5005
R1876 VSS.n1645 VSS.n1644 4.5005
R1877 VSS.n1646 VSS.n81 4.5005
R1878 VSS.n1648 VSS.n1647 4.5005
R1879 VSS.n1649 VSS.n80 4.5005
R1880 VSS.n1651 VSS.n1650 4.5005
R1881 VSS.n1652 VSS.n79 4.5005
R1882 VSS.n1654 VSS.n1653 4.5005
R1883 VSS.n1655 VSS.n78 4.5005
R1884 VSS.n1657 VSS.n1656 4.5005
R1885 VSS.n1658 VSS.n76 4.5005
R1886 VSS.n1519 VSS.n113 4.5005
R1887 VSS.n1521 VSS.n1520 4.5005
R1888 VSS.n1522 VSS.n112 4.5005
R1889 VSS.n1524 VSS.n1523 4.5005
R1890 VSS.n1525 VSS.n111 4.5005
R1891 VSS.n1401 VSS.n1400 4.5005
R1892 VSS.n1399 VSS.n154 4.5005
R1893 VSS.n1398 VSS.n1397 4.5005
R1894 VSS.n1396 VSS.n155 4.5005
R1895 VSS.n1395 VSS.n1394 4.5005
R1896 VSS.n1393 VSS.n156 4.5005
R1897 VSS.n1392 VSS.n1391 4.5005
R1898 VSS.n1390 VSS.n157 4.5005
R1899 VSS.n1389 VSS.n1388 4.5005
R1900 VSS.n1387 VSS.n158 4.5005
R1901 VSS.n1386 VSS.n1385 4.5005
R1902 VSS.n1384 VSS.n159 4.5005
R1903 VSS.n1383 VSS.n1382 4.5005
R1904 VSS.n1381 VSS.n160 4.5005
R1905 VSS.n1380 VSS.n1379 4.5005
R1906 VSS.n1378 VSS.n161 4.5005
R1907 VSS.n1377 VSS.n1376 4.5005
R1908 VSS.n1375 VSS.n162 4.5005
R1909 VSS.n1374 VSS.n1373 4.5005
R1910 VSS.n1372 VSS.n1371 4.5005
R1911 VSS.n1370 VSS.n1367 4.5005
R1912 VSS.n1369 VSS.n1368 4.5005
R1913 VSS.n134 VSS.n133 4.5005
R1914 VSS.n1412 VSS.n1411 4.5005
R1915 VSS.n1413 VSS.n132 4.5005
R1916 VSS.n1415 VSS.n1414 4.5005
R1917 VSS.n1416 VSS.n131 4.5005
R1918 VSS.n1418 VSS.n1417 4.5005
R1919 VSS.n1419 VSS.n130 4.5005
R1920 VSS.n1421 VSS.n1420 4.5005
R1921 VSS.n1422 VSS.n129 4.5005
R1922 VSS.n1424 VSS.n1423 4.5005
R1923 VSS.n1425 VSS.n128 4.5005
R1924 VSS.n1427 VSS.n1426 4.5005
R1925 VSS.n1428 VSS.n127 4.5005
R1926 VSS.n1430 VSS.n1429 4.5005
R1927 VSS.n1431 VSS.n126 4.5005
R1928 VSS.n1433 VSS.n1432 4.5005
R1929 VSS.n1434 VSS.n125 4.5005
R1930 VSS.n1436 VSS.n1435 4.5005
R1931 VSS.n1437 VSS.n124 4.5005
R1932 VSS.n1439 VSS.n1438 4.5005
R1933 VSS.n1440 VSS.n123 4.5005
R1934 VSS.n1442 VSS.n1441 4.5005
R1935 VSS.n1443 VSS.n122 4.5005
R1936 VSS.n1497 VSS.n1496 4.5005
R1937 VSS.n1498 VSS.n121 4.5005
R1938 VSS.n1500 VSS.n1499 4.5005
R1939 VSS.n1502 VSS.n1501 4.5005
R1940 VSS.n1503 VSS.n119 4.5005
R1941 VSS.n1505 VSS.n1504 4.5005
R1942 VSS.n1506 VSS.n118 4.5005
R1943 VSS.n1508 VSS.n1507 4.5005
R1944 VSS.n1509 VSS.n117 4.5005
R1945 VSS.n1511 VSS.n1510 4.5005
R1946 VSS.n1512 VSS.n115 4.5005
R1947 VSS.n1515 VSS.n1514 4.5005
R1948 VSS.n1516 VSS.n114 4.5005
R1949 VSS.n1518 VSS.n1517 4.5005
R1950 VSS.n1491 VSS.n2 4.5005
R1951 VSS.n1493 VSS.n2 4.5005
R1952 VSS.n1490 VSS.n1489 4.5005
R1953 VSS.n1492 VSS.n1491 4.5005
R1954 VSS.n1493 VSS.n1492 4.5005
R1955 VSS.n1445 VSS.n1444 3.94925
R1956 VSS.n449 VSS.n328 3.54125
R1957 VSS.n304 VSS.n193 3.54125
R1958 VSS.n1588 VSS.n74 3.54125
R1959 VSS.n1293 VSS.n193 3.54125
R1960 VSS.n1293 VSS.n194 3.54125
R1961 VSS.n1588 VSS.n1587 3.54125
R1962 VSS.n1587 VSS.n103 3.54125
R1963 VSS.n360 VSS.n194 3.54125
R1964 VSS.n360 VSS.n328 3.54125
R1965 VSS.n1409 VSS.n103 3.54125
R1966 VSS.n1807 VSS.n14 3.533
R1967 VSS.n1729 VSS.n1726 3.4003
R1968 VSS.n1751 VSS.n1750 3.4003
R1969 VSS.n1126 VSS.n75 3.3335
R1970 VSS.n1119 VSS.n1118 3.3335
R1971 VSS.n1133 VSS.n102 3.3335
R1972 VSS.n1111 VSS.n104 3.3335
R1973 VSS.n1140 VSS.n1139 3.3335
R1974 VSS.n1408 VSS.n136 3.3335
R1975 VSS.n1404 VSS.n152 3.3335
R1976 VSS.n1444 VSS.n14 3.00425
R1977 VSS.n1662 VSS.n74 2.96375
R1978 VSS.n1716 VSS.n1714 2.7005
R1979 VSS.n1477 VSS.n1476 2.7005
R1980 VSS.n1469 VSS.n16 2.7005
R1981 VSS.n1803 VSS.n17 2.7005
R1982 VSS.n1409 VSS.n135 2.44325
R1983 VSS.n1804 VSS.n16 2.2955
R1984 VSS.n1789 VSS.n25 2.28425
R1985 VSS.n1830 VSS.n1829 2.17304
R1986 VSS.n144 VSS.t260 2.02992
R1987 VSS.n1494 VSS.n1493 1.97997
R1988 VSS.n1710 VSS.n0 0.930804
R1989 VSS.n1486 VSS.n1446 1.8005
R1990 VSS.n1791 VSS.n24 1.778
R1991 VSS.n1712 VSS.t153 1.712
R1992 VSS.n1791 VSS.n1790 1.598
R1993 VSS.n142 VSS.t261 1.46663
R1994 VSS.n1476 VSS.n1454 1.4405
R1995 VSS.n1127 VSS.n1126 1.36464
R1996 VSS.n1120 VSS.n1119 1.36464
R1997 VSS.n1134 VSS.n1133 1.36464
R1998 VSS.n1112 VSS.n1111 1.36464
R1999 VSS.n1141 VSS.n1140 1.36464
R2000 VSS.n137 VSS.n136 1.36464
R2001 VSS.n152 VSS.n151 1.36464
R2002 VSS.n1829 VSS.n1828 1.3028
R2003 VSS.n143 VSS.n141 1.29346
R2004 VSS.n1667 VSS.t255 1.26595
R2005 VSS.n1469 VSS.n1454 1.2605
R2006 VSS.n1488 VSS.n1486 1.1705
R2007 VSS.n326 VSS.t131 1.16433
R2008 VSS.n311 VSS.t198 1.16433
R2009 VSS.n316 VSS.t91 1.16433
R2010 VSS.n306 VSS.t145 1.16433
R2011 VSS.n195 VSS.t216 1.16433
R2012 VSS.n358 VSS.t43 1.16433
R2013 VSS.n451 VSS.t173 1.16433
R2014 VSS.n1790 VSS.n1789 1.103
R2015 VSS.n303 VSS.n203 1.08917
R2016 VSS.n1660 VSS.n1659 1.08917
R2017 VSS.n1777 VSS.t238 1.05964
R2018 VSS.n1403 VSS.n135 1.0085
R2019 VSS.n308 VSS.n307 0.980265
R2020 VSS.n495 VSS.n494 0.980265
R2021 VSS.n520 VSS.n518 0.980265
R2022 VSS.n545 VSS.n543 0.980265
R2023 VSS.n570 VSS.n568 0.980265
R2024 VSS.n608 VSS.n607 0.980265
R2025 VSS.n632 VSS.n631 0.980265
R2026 VSS.n657 VSS.n655 0.980265
R2027 VSS.n682 VSS.n680 0.980265
R2028 VSS.n707 VSS.n705 0.980265
R2029 VSS.n745 VSS.n744 0.980265
R2030 VSS.n770 VSS.n769 0.980265
R2031 VSS.n794 VSS.n793 0.980265
R2032 VSS.n819 VSS.n817 0.980265
R2033 VSS.n844 VSS.n842 0.980265
R2034 VSS.n882 VSS.n881 0.980265
R2035 VSS.n907 VSS.n906 0.980265
R2036 VSS.n931 VSS.n930 0.980265
R2037 VSS.n956 VSS.n954 0.980265
R2038 VSS.n981 VSS.n979 0.980265
R2039 VSS.n1019 VSS.n1018 0.980265
R2040 VSS.n1044 VSS.n1043 0.980265
R2041 VSS.n1068 VSS.n1067 0.980265
R2042 VSS.n1093 VSS.n1091 0.980265
R2043 VSS.n1125 VSS.n1123 0.980265
R2044 VSS.n466 VSS.n465 0.980265
R2045 VSS.n490 VSS.n489 0.980265
R2046 VSS.n515 VSS.n513 0.980265
R2047 VSS.n540 VSS.n538 0.980265
R2048 VSS.n565 VSS.n563 0.980265
R2049 VSS.n603 VSS.n602 0.980265
R2050 VSS.n627 VSS.n626 0.980265
R2051 VSS.n652 VSS.n650 0.980265
R2052 VSS.n677 VSS.n675 0.980265
R2053 VSS.n702 VSS.n700 0.980265
R2054 VSS.n740 VSS.n739 0.980265
R2055 VSS.n765 VSS.n764 0.980265
R2056 VSS.n789 VSS.n788 0.980265
R2057 VSS.n814 VSS.n812 0.980265
R2058 VSS.n839 VSS.n837 0.980265
R2059 VSS.n877 VSS.n876 0.980265
R2060 VSS.n902 VSS.n901 0.980265
R2061 VSS.n926 VSS.n925 0.980265
R2062 VSS.n951 VSS.n949 0.980265
R2063 VSS.n976 VSS.n974 0.980265
R2064 VSS.n1014 VSS.n1013 0.980265
R2065 VSS.n1039 VSS.n1038 0.980265
R2066 VSS.n1063 VSS.n1062 0.980265
R2067 VSS.n1088 VSS.n1086 0.980265
R2068 VSS.n1117 VSS.n1115 0.980265
R2069 VSS.n473 VSS.n472 0.980265
R2070 VSS.n499 VSS.n498 0.980265
R2071 VSS.n524 VSS.n522 0.980265
R2072 VSS.n549 VSS.n547 0.980265
R2073 VSS.n574 VSS.n572 0.980265
R2074 VSS.n612 VSS.n611 0.980265
R2075 VSS.n636 VSS.n635 0.980265
R2076 VSS.n661 VSS.n659 0.980265
R2077 VSS.n686 VSS.n684 0.980265
R2078 VSS.n711 VSS.n709 0.980265
R2079 VSS.n749 VSS.n748 0.980265
R2080 VSS.n774 VSS.n773 0.980265
R2081 VSS.n798 VSS.n797 0.980265
R2082 VSS.n823 VSS.n821 0.980265
R2083 VSS.n848 VSS.n846 0.980265
R2084 VSS.n886 VSS.n885 0.980265
R2085 VSS.n911 VSS.n910 0.980265
R2086 VSS.n935 VSS.n934 0.980265
R2087 VSS.n960 VSS.n958 0.980265
R2088 VSS.n985 VSS.n983 0.980265
R2089 VSS.n1023 VSS.n1022 0.980265
R2090 VSS.n1048 VSS.n1047 0.980265
R2091 VSS.n1072 VSS.n1071 0.980265
R2092 VSS.n1097 VSS.n1095 0.980265
R2093 VSS.n1132 VSS.n1130 0.980265
R2094 VSS.n462 VSS.n461 0.980265
R2095 VSS.n486 VSS.n485 0.980265
R2096 VSS.n511 VSS.n509 0.980265
R2097 VSS.n536 VSS.n534 0.980265
R2098 VSS.n561 VSS.n559 0.980265
R2099 VSS.n599 VSS.n598 0.980265
R2100 VSS.n623 VSS.n622 0.980265
R2101 VSS.n648 VSS.n646 0.980265
R2102 VSS.n673 VSS.n671 0.980265
R2103 VSS.n698 VSS.n696 0.980265
R2104 VSS.n736 VSS.n735 0.980265
R2105 VSS.n761 VSS.n760 0.980265
R2106 VSS.n785 VSS.n784 0.980265
R2107 VSS.n810 VSS.n808 0.980265
R2108 VSS.n835 VSS.n833 0.980265
R2109 VSS.n873 VSS.n872 0.980265
R2110 VSS.n898 VSS.n897 0.980265
R2111 VSS.n922 VSS.n921 0.980265
R2112 VSS.n947 VSS.n945 0.980265
R2113 VSS.n972 VSS.n970 0.980265
R2114 VSS.n1010 VSS.n1009 0.980265
R2115 VSS.n1035 VSS.n1034 0.980265
R2116 VSS.n1059 VSS.n1058 0.980265
R2117 VSS.n1084 VSS.n1082 0.980265
R2118 VSS.n1110 VSS.n1108 0.980265
R2119 VSS.n477 VSS.n476 0.980265
R2120 VSS.n1278 VSS.n479 0.980265
R2121 VSS.n527 VSS.n526 0.980265
R2122 VSS.n1267 VSS.n528 0.980265
R2123 VSS.n577 VSS.n576 0.980265
R2124 VSS.n579 VSS.n578 0.980265
R2125 VSS.n1249 VSS.n616 0.980265
R2126 VSS.n664 VSS.n663 0.980265
R2127 VSS.n1238 VSS.n665 0.980265
R2128 VSS.n714 VSS.n713 0.980265
R2129 VSS.n716 VSS.n715 0.980265
R2130 VSS.n1220 VSS.n753 0.980265
R2131 VSS.n755 VSS.n754 0.980265
R2132 VSS.n1209 VSS.n802 0.980265
R2133 VSS.n851 VSS.n850 0.980265
R2134 VSS.n853 VSS.n852 0.980265
R2135 VSS.n1191 VSS.n890 0.980265
R2136 VSS.n892 VSS.n891 0.980265
R2137 VSS.n1180 VSS.n939 0.980265
R2138 VSS.n988 VSS.n987 0.980265
R2139 VSS.n990 VSS.n989 0.980265
R2140 VSS.n1162 VSS.n1027 0.980265
R2141 VSS.n1029 VSS.n1028 0.980265
R2142 VSS.n1151 VSS.n1076 0.980265
R2143 VSS.n1138 VSS.n1137 0.980265
R2144 VSS.n458 VSS.n457 0.980265
R2145 VSS.n482 VSS.n481 0.980265
R2146 VSS.n507 VSS.n505 0.980265
R2147 VSS.n532 VSS.n530 0.980265
R2148 VSS.n557 VSS.n555 0.980265
R2149 VSS.n595 VSS.n594 0.980265
R2150 VSS.n619 VSS.n618 0.980265
R2151 VSS.n644 VSS.n642 0.980265
R2152 VSS.n669 VSS.n667 0.980265
R2153 VSS.n694 VSS.n692 0.980265
R2154 VSS.n732 VSS.n731 0.980265
R2155 VSS.n757 VSS.n756 0.980265
R2156 VSS.n781 VSS.n780 0.980265
R2157 VSS.n806 VSS.n804 0.980265
R2158 VSS.n831 VSS.n829 0.980265
R2159 VSS.n869 VSS.n868 0.980265
R2160 VSS.n894 VSS.n893 0.980265
R2161 VSS.n918 VSS.n917 0.980265
R2162 VSS.n943 VSS.n941 0.980265
R2163 VSS.n968 VSS.n966 0.980265
R2164 VSS.n1006 VSS.n1005 0.980265
R2165 VSS.n1031 VSS.n1030 0.980265
R2166 VSS.n1055 VSS.n1054 0.980265
R2167 VSS.n1080 VSS.n1078 0.980265
R2168 VSS.n1105 VSS.n1103 0.980265
R2169 VSS.n1283 VSS.n454 0.980265
R2170 VSS.n456 VSS.n455 0.980265
R2171 VSS.n1272 VSS.n503 0.980265
R2172 VSS.n552 VSS.n551 0.980265
R2173 VSS.n1262 VSS.n553 0.980265
R2174 VSS.n1254 VSS.n591 0.980265
R2175 VSS.n593 VSS.n592 0.980265
R2176 VSS.n1243 VSS.n640 0.980265
R2177 VSS.n689 VSS.n688 0.980265
R2178 VSS.n1233 VSS.n690 0.980265
R2179 VSS.n1225 VSS.n728 0.980265
R2180 VSS.n730 VSS.n729 0.980265
R2181 VSS.n1215 VSS.n778 0.980265
R2182 VSS.n826 VSS.n825 0.980265
R2183 VSS.n1204 VSS.n827 0.980265
R2184 VSS.n1196 VSS.n865 0.980265
R2185 VSS.n867 VSS.n866 0.980265
R2186 VSS.n1186 VSS.n915 0.980265
R2187 VSS.n963 VSS.n962 0.980265
R2188 VSS.n1175 VSS.n964 0.980265
R2189 VSS.n1167 VSS.n1002 0.980265
R2190 VSS.n1004 VSS.n1003 0.980265
R2191 VSS.n1157 VSS.n1052 0.980265
R2192 VSS.n1100 VSS.n1099 0.980265
R2193 VSS.n1146 VSS.n1101 0.980265
R2194 VSS.n1755 VSS.t258 0.97765
R2195 VSS.n0 VSS.t154 0.306617
R2196 VSS.n1711 VSS.n59 0.967665
R2197 VSS.n24 VSS.n17 0.923
R2198 VSS.n1485 VSS.n1447 0.9005
R2199 VSS.n1485 VSS.n1484 0.9005
R2200 VSS.n1484 VSS.n1450 0.9005
R2201 VSS.n1480 VSS.n1450 0.9005
R2202 VSS.n1480 VSS.n1451 0.9005
R2203 VSS.n1455 VSS.n1451 0.9005
R2204 VSS.n1475 VSS.n1455 0.9005
R2205 VSS.n1475 VSS.n1474 0.9005
R2206 VSS.n1474 VSS.n1459 0.9005
R2207 VSS.n1470 VSS.n1459 0.9005
R2208 VSS.n1470 VSS.n1468 0.9005
R2209 VSS.n1468 VSS.n1467 0.9005
R2210 VSS.n1467 VSS.n1461 0.9005
R2211 VSS.n1463 VSS.n1461 0.9005
R2212 VSS.n1463 VSS.n18 0.9005
R2213 VSS.n1802 VSS.n18 0.9005
R2214 VSS.n1802 VSS.n1801 0.9005
R2215 VSS.n1801 VSS.n20 0.9005
R2216 VSS.n1797 VSS.n20 0.9005
R2217 VSS.n1797 VSS.n1796 0.9005
R2218 VSS.n1796 VSS.n21 0.9005
R2219 VSS.n1792 VSS.n21 0.9005
R2220 VSS.n1792 VSS.n23 0.9005
R2221 VSS.n26 VSS.n23 0.9005
R2222 VSS.n1788 VSS.n26 0.9005
R2223 VSS.n1788 VSS.n1787 0.9005
R2224 VSS.n1787 VSS.n29 0.9005
R2225 VSS.n1783 VSS.n29 0.9005
R2226 VSS.n1783 VSS.n31 0.9005
R2227 VSS.n35 VSS.n31 0.9005
R2228 VSS.n36 VSS.n35 0.9005
R2229 VSS.n1477 VSS.n1446 0.9005
R2230 VSS.n142 VSS.n135 0.8075
R2231 VSS.n145 VSS.t0 0.695538
R2232 VSS.n71 VSS.n57 0.6755
R2233 VSS.n64 VSS.n57 0.6755
R2234 VSS.n1705 VSS.n64 0.6755
R2235 VSS.n1706 VSS.n1705 0.6755
R2236 VSS.n1706 VSS.n58 0.6755
R2237 VSS.n1690 VSS.n58 0.6755
R2238 VSS.n1691 VSS.n1690 0.6755
R2239 VSS.n1691 VSS.n56 0.6755
R2240 VSS.n1717 VSS.n56 0.6755
R2241 VSS.n143 VSS.n142 0.6449
R2242 VSS.n448 VSS.n329 0.612794
R2243 VSS.n1402 VSS.n153 0.612794
R2244 VSS.n1662 VSS.n1661 0.578
R2245 VSS.n6 VSS.n3 0.575
R2246 VSS.n1715 VSS.n1 0.563
R2247 VSS.n67 VSS.n66 0.535665
R2248 VSS.n1700 VSS.n1676 0.535665
R2249 VSS.n1678 VSS.n1677 0.535665
R2250 VSS.n1687 VSS.n1686 0.535665
R2251 VSS.n1721 VSS.n52 0.535665
R2252 VSS.n1724 VSS.n1723 0.535665
R2253 VSS.n1730 VSS.n1725 0.535665
R2254 VSS.n1728 VSS.n1727 0.535665
R2255 VSS.n13 VSS.n12 0.535665
R2256 VSS.n1747 VSS.n1746 0.535665
R2257 VSS.n1749 VSS.n1748 0.535665
R2258 VSS.n1744 VSS.n1743 0.535665
R2259 VSS.n1757 VSS.n49 0.535665
R2260 VSS.n47 VSS.n46 0.535665
R2261 VSS.n1764 VSS.n45 0.535665
R2262 VSS.n1770 VSS.n42 0.535665
R2263 VSS.n40 VSS.n39 0.535665
R2264 VSS.n66 VSS.t254 0.4793
R2265 VSS.n66 VSS.t255 0.4793
R2266 VSS.n1676 VSS.t253 0.4793
R2267 VSS.n1676 VSS.t254 0.4793
R2268 VSS.n1677 VSS.t252 0.4793
R2269 VSS.n1677 VSS.t253 0.4793
R2270 VSS.n1686 VSS.t251 0.4793
R2271 VSS.n1686 VSS.t252 0.4793
R2272 VSS.n52 VSS.t250 0.4793
R2273 VSS.n52 VSS.t251 0.4793
R2274 VSS.n1723 VSS.t249 0.4793
R2275 VSS.n1723 VSS.t250 0.4793
R2276 VSS.n1725 VSS.t248 0.4793
R2277 VSS.n1725 VSS.t249 0.4793
R2278 VSS.n1727 VSS.t247 0.4793
R2279 VSS.n1727 VSS.t248 0.4793
R2280 VSS.n12 VSS.t246 0.4793
R2281 VSS.n12 VSS.t247 0.4793
R2282 VSS.n1746 VSS.t245 0.4793
R2283 VSS.n1746 VSS.t246 0.4793
R2284 VSS.n1748 VSS.t244 0.4793
R2285 VSS.n1748 VSS.t245 0.4793
R2286 VSS.n1743 VSS.t243 0.4793
R2287 VSS.n1743 VSS.t244 0.4793
R2288 VSS.n49 VSS.t242 0.4793
R2289 VSS.n49 VSS.t243 0.4793
R2290 VSS.n46 VSS.t241 0.4793
R2291 VSS.n46 VSS.t242 0.4793
R2292 VSS.n45 VSS.t240 0.4793
R2293 VSS.n45 VSS.t241 0.4793
R2294 VSS.n42 VSS.t239 0.4793
R2295 VSS.n42 VSS.t240 0.4793
R2296 VSS.n39 VSS.t238 0.4793
R2297 VSS.n39 VSS.t239 0.4793
R2298 VSS.n1782 VSS.n1781 0.4505
R2299 VSS.n1807 VSS.n1806 0.43925
R2300 VSS.n1495 VSS.n1494 0.4255
R2301 VSS.n1782 VSS.n25 0.41675
R2302 VSS.n1804 VSS.n1803 0.4055
R2303 VSS.n1806 VSS.n1805 0.37175
R2304 VSS.n146 VSS.n144 0.3605
R2305 VSS.n1672 VSS.n1671 0.3605
R2306 VSS.n1672 VSS.n60 0.3605
R2307 VSS.n1709 VSS.n61 0.3605
R2308 VSS.n1694 VSS.n61 0.3605
R2309 VSS.n1830 VSS.n2 0.3255
R2310 VSS.n1711 VSS.n1710 0.3011
R2311 VSS.n152 VSS.t237 0.288377
R2312 VSS.n1140 VSS.t130 0.288377
R2313 VSS.n1133 VSS.t197 0.288377
R2314 VSS.n1126 VSS.t90 0.288377
R2315 VSS.n1119 VSS.t215 0.288377
R2316 VSS.n1111 VSS.t42 0.288377
R2317 VSS.n136 VSS.t172 0.288377
R2318 VSS.n144 VSS.n73 0.274336
R2319 VSS.n305 VSS.n304 0.2405
R2320 VSS.n1661 VSS.n75 0.2405
R2321 VSS.n1118 VSS.n74 0.2405
R2322 VSS.n315 VSS.n193 0.2405
R2323 VSS.n1293 VSS.n1292 0.2405
R2324 VSS.n1588 VSS.n102 0.2405
R2325 VSS.n1587 VSS.n104 0.2405
R2326 VSS.n310 VSS.n194 0.2405
R2327 VSS.n360 VSS.n359 0.2405
R2328 VSS.n1139 VSS.n103 0.2405
R2329 VSS.n1409 VSS.n1408 0.2405
R2330 VSS.n328 VSS.n327 0.2405
R2331 VSS.n450 VSS.n449 0.2405
R2332 VSS.n1404 VSS.n1403 0.2405
R2333 VSS.n0 VSS.t155 0.141508
R2334 VSS.n59 VSS.t153 0.2324
R2335 VSS.n59 VSS.t154 0.2324
R2336 VSS.n307 VSS.t146 0.227306
R2337 VSS.n307 VSS.t145 0.227306
R2338 VSS.n494 VSS.t147 0.227306
R2339 VSS.n494 VSS.t146 0.227306
R2340 VSS.n518 VSS.t148 0.227306
R2341 VSS.n518 VSS.t147 0.227306
R2342 VSS.n543 VSS.t149 0.227306
R2343 VSS.n543 VSS.t148 0.227306
R2344 VSS.n568 VSS.t150 0.227306
R2345 VSS.n568 VSS.t149 0.227306
R2346 VSS.n607 VSS.t151 0.227306
R2347 VSS.n607 VSS.t150 0.227306
R2348 VSS.n631 VSS.t104 0.227306
R2349 VSS.n631 VSS.t151 0.227306
R2350 VSS.n655 VSS.t105 0.227306
R2351 VSS.n655 VSS.t104 0.227306
R2352 VSS.n680 VSS.t106 0.227306
R2353 VSS.n680 VSS.t105 0.227306
R2354 VSS.n705 VSS.t107 0.227306
R2355 VSS.n705 VSS.t106 0.227306
R2356 VSS.n744 VSS.t108 0.227306
R2357 VSS.n744 VSS.t107 0.227306
R2358 VSS.n769 VSS.t109 0.227306
R2359 VSS.n769 VSS.t108 0.227306
R2360 VSS.n793 VSS.t110 0.227306
R2361 VSS.n793 VSS.t109 0.227306
R2362 VSS.n817 VSS.t111 0.227306
R2363 VSS.n817 VSS.t110 0.227306
R2364 VSS.n842 VSS.t96 0.227306
R2365 VSS.n842 VSS.t111 0.227306
R2366 VSS.n881 VSS.t97 0.227306
R2367 VSS.n881 VSS.t96 0.227306
R2368 VSS.n906 VSS.t98 0.227306
R2369 VSS.n906 VSS.t97 0.227306
R2370 VSS.n930 VSS.t99 0.227306
R2371 VSS.n930 VSS.t98 0.227306
R2372 VSS.n954 VSS.t100 0.227306
R2373 VSS.n954 VSS.t99 0.227306
R2374 VSS.n979 VSS.t101 0.227306
R2375 VSS.n979 VSS.t100 0.227306
R2376 VSS.n1018 VSS.t102 0.227306
R2377 VSS.n1018 VSS.t101 0.227306
R2378 VSS.n1043 VSS.t103 0.227306
R2379 VSS.n1043 VSS.t102 0.227306
R2380 VSS.n1067 VSS.t88 0.227306
R2381 VSS.n1067 VSS.t103 0.227306
R2382 VSS.n1091 VSS.t89 0.227306
R2383 VSS.n1091 VSS.t88 0.227306
R2384 VSS.n1123 VSS.t90 0.227306
R2385 VSS.n1123 VSS.t89 0.227306
R2386 VSS.n465 VSS.t92 0.227306
R2387 VSS.n465 VSS.t91 0.227306
R2388 VSS.n489 VSS.t93 0.227306
R2389 VSS.n489 VSS.t92 0.227306
R2390 VSS.n513 VSS.t94 0.227306
R2391 VSS.n513 VSS.t93 0.227306
R2392 VSS.n538 VSS.t95 0.227306
R2393 VSS.n538 VSS.t94 0.227306
R2394 VSS.n563 VSS.t112 0.227306
R2395 VSS.n563 VSS.t95 0.227306
R2396 VSS.n602 VSS.t113 0.227306
R2397 VSS.n602 VSS.t112 0.227306
R2398 VSS.n626 VSS.t114 0.227306
R2399 VSS.n626 VSS.t113 0.227306
R2400 VSS.n650 VSS.t115 0.227306
R2401 VSS.n650 VSS.t114 0.227306
R2402 VSS.n675 VSS.t116 0.227306
R2403 VSS.n675 VSS.t115 0.227306
R2404 VSS.n700 VSS.t117 0.227306
R2405 VSS.n700 VSS.t116 0.227306
R2406 VSS.n739 VSS.t118 0.227306
R2407 VSS.n739 VSS.t117 0.227306
R2408 VSS.n764 VSS.t119 0.227306
R2409 VSS.n764 VSS.t118 0.227306
R2410 VSS.n788 VSS.t22 0.227306
R2411 VSS.n788 VSS.t119 0.227306
R2412 VSS.n812 VSS.t23 0.227306
R2413 VSS.n812 VSS.t22 0.227306
R2414 VSS.n837 VSS.t24 0.227306
R2415 VSS.n837 VSS.t23 0.227306
R2416 VSS.n876 VSS.t25 0.227306
R2417 VSS.n876 VSS.t24 0.227306
R2418 VSS.n901 VSS.t26 0.227306
R2419 VSS.n901 VSS.t25 0.227306
R2420 VSS.n925 VSS.t27 0.227306
R2421 VSS.n925 VSS.t26 0.227306
R2422 VSS.n949 VSS.t28 0.227306
R2423 VSS.n949 VSS.t27 0.227306
R2424 VSS.n974 VSS.t29 0.227306
R2425 VSS.n974 VSS.t28 0.227306
R2426 VSS.n1013 VSS.t211 0.227306
R2427 VSS.n1013 VSS.t29 0.227306
R2428 VSS.n1038 VSS.t212 0.227306
R2429 VSS.n1038 VSS.t211 0.227306
R2430 VSS.n1062 VSS.t213 0.227306
R2431 VSS.n1062 VSS.t212 0.227306
R2432 VSS.n1086 VSS.t214 0.227306
R2433 VSS.n1086 VSS.t213 0.227306
R2434 VSS.n1115 VSS.t215 0.227306
R2435 VSS.n1115 VSS.t214 0.227306
R2436 VSS.n472 VSS.t217 0.227306
R2437 VSS.n472 VSS.t216 0.227306
R2438 VSS.n498 VSS.t218 0.227306
R2439 VSS.n498 VSS.t217 0.227306
R2440 VSS.n522 VSS.t160 0.227306
R2441 VSS.n522 VSS.t218 0.227306
R2442 VSS.n547 VSS.t161 0.227306
R2443 VSS.n547 VSS.t160 0.227306
R2444 VSS.n572 VSS.t162 0.227306
R2445 VSS.n572 VSS.t161 0.227306
R2446 VSS.n611 VSS.t163 0.227306
R2447 VSS.n611 VSS.t162 0.227306
R2448 VSS.n635 VSS.t164 0.227306
R2449 VSS.n635 VSS.t163 0.227306
R2450 VSS.n659 VSS.t165 0.227306
R2451 VSS.n659 VSS.t164 0.227306
R2452 VSS.n684 VSS.t166 0.227306
R2453 VSS.n684 VSS.t165 0.227306
R2454 VSS.n709 VSS.t167 0.227306
R2455 VSS.n709 VSS.t166 0.227306
R2456 VSS.n748 VSS.t136 0.227306
R2457 VSS.n748 VSS.t167 0.227306
R2458 VSS.n773 VSS.t137 0.227306
R2459 VSS.n773 VSS.t136 0.227306
R2460 VSS.n797 VSS.t138 0.227306
R2461 VSS.n797 VSS.t137 0.227306
R2462 VSS.n821 VSS.t139 0.227306
R2463 VSS.n821 VSS.t138 0.227306
R2464 VSS.n846 VSS.t140 0.227306
R2465 VSS.n846 VSS.t139 0.227306
R2466 VSS.n885 VSS.t141 0.227306
R2467 VSS.n885 VSS.t140 0.227306
R2468 VSS.n910 VSS.t142 0.227306
R2469 VSS.n910 VSS.t141 0.227306
R2470 VSS.n934 VSS.t143 0.227306
R2471 VSS.n934 VSS.t142 0.227306
R2472 VSS.n958 VSS.t191 0.227306
R2473 VSS.n958 VSS.t143 0.227306
R2474 VSS.n983 VSS.t192 0.227306
R2475 VSS.n983 VSS.t191 0.227306
R2476 VSS.n1022 VSS.t193 0.227306
R2477 VSS.n1022 VSS.t192 0.227306
R2478 VSS.n1047 VSS.t194 0.227306
R2479 VSS.n1047 VSS.t193 0.227306
R2480 VSS.n1071 VSS.t195 0.227306
R2481 VSS.n1071 VSS.t194 0.227306
R2482 VSS.n1095 VSS.t196 0.227306
R2483 VSS.n1095 VSS.t195 0.227306
R2484 VSS.n1130 VSS.t197 0.227306
R2485 VSS.n1130 VSS.t196 0.227306
R2486 VSS.n461 VSS.t76 0.227306
R2487 VSS.n461 VSS.t198 0.227306
R2488 VSS.n485 VSS.t77 0.227306
R2489 VSS.n485 VSS.t76 0.227306
R2490 VSS.n509 VSS.t78 0.227306
R2491 VSS.n509 VSS.t77 0.227306
R2492 VSS.n534 VSS.t79 0.227306
R2493 VSS.n534 VSS.t78 0.227306
R2494 VSS.n559 VSS.t80 0.227306
R2495 VSS.n559 VSS.t79 0.227306
R2496 VSS.n598 VSS.t81 0.227306
R2497 VSS.n598 VSS.t80 0.227306
R2498 VSS.n622 VSS.t82 0.227306
R2499 VSS.n622 VSS.t81 0.227306
R2500 VSS.n646 VSS.t83 0.227306
R2501 VSS.n646 VSS.t82 0.227306
R2502 VSS.n671 VSS.t199 0.227306
R2503 VSS.n671 VSS.t83 0.227306
R2504 VSS.n696 VSS.t200 0.227306
R2505 VSS.n696 VSS.t199 0.227306
R2506 VSS.n735 VSS.t201 0.227306
R2507 VSS.n735 VSS.t200 0.227306
R2508 VSS.n760 VSS.t202 0.227306
R2509 VSS.n760 VSS.t201 0.227306
R2510 VSS.n784 VSS.t203 0.227306
R2511 VSS.n784 VSS.t202 0.227306
R2512 VSS.n808 VSS.t204 0.227306
R2513 VSS.n808 VSS.t203 0.227306
R2514 VSS.n833 VSS.t205 0.227306
R2515 VSS.n833 VSS.t204 0.227306
R2516 VSS.n872 VSS.t206 0.227306
R2517 VSS.n872 VSS.t205 0.227306
R2518 VSS.n897 VSS.t11 0.227306
R2519 VSS.n897 VSS.t206 0.227306
R2520 VSS.n921 VSS.t12 0.227306
R2521 VSS.n921 VSS.t11 0.227306
R2522 VSS.n945 VSS.t13 0.227306
R2523 VSS.n945 VSS.t12 0.227306
R2524 VSS.n970 VSS.t14 0.227306
R2525 VSS.n970 VSS.t13 0.227306
R2526 VSS.n1009 VSS.t15 0.227306
R2527 VSS.n1009 VSS.t14 0.227306
R2528 VSS.n1034 VSS.t16 0.227306
R2529 VSS.n1034 VSS.t15 0.227306
R2530 VSS.n1058 VSS.t17 0.227306
R2531 VSS.n1058 VSS.t16 0.227306
R2532 VSS.n1082 VSS.t18 0.227306
R2533 VSS.n1082 VSS.t17 0.227306
R2534 VSS.n1108 VSS.t42 0.227306
R2535 VSS.n1108 VSS.t18 0.227306
R2536 VSS.n476 VSS.t44 0.227306
R2537 VSS.n476 VSS.t43 0.227306
R2538 VSS.n479 VSS.t45 0.227306
R2539 VSS.n479 VSS.t44 0.227306
R2540 VSS.n526 VSS.t46 0.227306
R2541 VSS.n526 VSS.t45 0.227306
R2542 VSS.n528 VSS.t47 0.227306
R2543 VSS.n528 VSS.t46 0.227306
R2544 VSS.n576 VSS.t48 0.227306
R2545 VSS.n576 VSS.t47 0.227306
R2546 VSS.n578 VSS.t49 0.227306
R2547 VSS.n578 VSS.t48 0.227306
R2548 VSS.n616 VSS.t180 0.227306
R2549 VSS.n616 VSS.t49 0.227306
R2550 VSS.n663 VSS.t181 0.227306
R2551 VSS.n663 VSS.t180 0.227306
R2552 VSS.n665 VSS.t182 0.227306
R2553 VSS.n665 VSS.t181 0.227306
R2554 VSS.n713 VSS.t183 0.227306
R2555 VSS.n713 VSS.t182 0.227306
R2556 VSS.n715 VSS.t184 0.227306
R2557 VSS.n715 VSS.t183 0.227306
R2558 VSS.n753 VSS.t185 0.227306
R2559 VSS.n753 VSS.t184 0.227306
R2560 VSS.n754 VSS.t186 0.227306
R2561 VSS.n754 VSS.t185 0.227306
R2562 VSS.n802 VSS.t187 0.227306
R2563 VSS.n802 VSS.t186 0.227306
R2564 VSS.n850 VSS.t2 0.227306
R2565 VSS.n850 VSS.t187 0.227306
R2566 VSS.n852 VSS.t3 0.227306
R2567 VSS.n852 VSS.t2 0.227306
R2568 VSS.n890 VSS.t4 0.227306
R2569 VSS.n890 VSS.t3 0.227306
R2570 VSS.n891 VSS.t5 0.227306
R2571 VSS.n891 VSS.t4 0.227306
R2572 VSS.n939 VSS.t6 0.227306
R2573 VSS.n939 VSS.t5 0.227306
R2574 VSS.n987 VSS.t7 0.227306
R2575 VSS.n987 VSS.t6 0.227306
R2576 VSS.n989 VSS.t8 0.227306
R2577 VSS.n989 VSS.t7 0.227306
R2578 VSS.n1027 VSS.t9 0.227306
R2579 VSS.n1027 VSS.t8 0.227306
R2580 VSS.n1028 VSS.t128 0.227306
R2581 VSS.n1028 VSS.t9 0.227306
R2582 VSS.n1076 VSS.t129 0.227306
R2583 VSS.n1076 VSS.t128 0.227306
R2584 VSS.n1137 VSS.t130 0.227306
R2585 VSS.n1137 VSS.t129 0.227306
R2586 VSS.n457 VSS.t132 0.227306
R2587 VSS.n457 VSS.t131 0.227306
R2588 VSS.n481 VSS.t133 0.227306
R2589 VSS.n481 VSS.t132 0.227306
R2590 VSS.n505 VSS.t134 0.227306
R2591 VSS.n505 VSS.t133 0.227306
R2592 VSS.n530 VSS.t135 0.227306
R2593 VSS.n530 VSS.t134 0.227306
R2594 VSS.n555 VSS.t68 0.227306
R2595 VSS.n555 VSS.t135 0.227306
R2596 VSS.n594 VSS.t69 0.227306
R2597 VSS.n594 VSS.t68 0.227306
R2598 VSS.n618 VSS.t70 0.227306
R2599 VSS.n618 VSS.t69 0.227306
R2600 VSS.n642 VSS.t71 0.227306
R2601 VSS.n642 VSS.t70 0.227306
R2602 VSS.n667 VSS.t72 0.227306
R2603 VSS.n667 VSS.t71 0.227306
R2604 VSS.n692 VSS.t73 0.227306
R2605 VSS.n692 VSS.t72 0.227306
R2606 VSS.n731 VSS.t74 0.227306
R2607 VSS.n731 VSS.t73 0.227306
R2608 VSS.n756 VSS.t75 0.227306
R2609 VSS.n756 VSS.t74 0.227306
R2610 VSS.n780 VSS.t60 0.227306
R2611 VSS.n780 VSS.t75 0.227306
R2612 VSS.n804 VSS.t61 0.227306
R2613 VSS.n804 VSS.t60 0.227306
R2614 VSS.n829 VSS.t62 0.227306
R2615 VSS.n829 VSS.t61 0.227306
R2616 VSS.n868 VSS.t63 0.227306
R2617 VSS.n868 VSS.t62 0.227306
R2618 VSS.n893 VSS.t64 0.227306
R2619 VSS.n893 VSS.t63 0.227306
R2620 VSS.n917 VSS.t65 0.227306
R2621 VSS.n917 VSS.t64 0.227306
R2622 VSS.n941 VSS.t66 0.227306
R2623 VSS.n941 VSS.t65 0.227306
R2624 VSS.n966 VSS.t67 0.227306
R2625 VSS.n966 VSS.t66 0.227306
R2626 VSS.n1005 VSS.t168 0.227306
R2627 VSS.n1005 VSS.t67 0.227306
R2628 VSS.n1030 VSS.t169 0.227306
R2629 VSS.n1030 VSS.t168 0.227306
R2630 VSS.n1054 VSS.t170 0.227306
R2631 VSS.n1054 VSS.t169 0.227306
R2632 VSS.n1078 VSS.t171 0.227306
R2633 VSS.n1078 VSS.t170 0.227306
R2634 VSS.n1103 VSS.t172 0.227306
R2635 VSS.n1103 VSS.t171 0.227306
R2636 VSS.n454 VSS.t174 0.227306
R2637 VSS.n454 VSS.t173 0.227306
R2638 VSS.n455 VSS.t175 0.227306
R2639 VSS.n455 VSS.t174 0.227306
R2640 VSS.n503 VSS.t120 0.227306
R2641 VSS.n503 VSS.t175 0.227306
R2642 VSS.n551 VSS.t121 0.227306
R2643 VSS.n551 VSS.t120 0.227306
R2644 VSS.n553 VSS.t122 0.227306
R2645 VSS.n553 VSS.t121 0.227306
R2646 VSS.n591 VSS.t123 0.227306
R2647 VSS.n591 VSS.t122 0.227306
R2648 VSS.n592 VSS.t124 0.227306
R2649 VSS.n592 VSS.t123 0.227306
R2650 VSS.n640 VSS.t125 0.227306
R2651 VSS.n640 VSS.t124 0.227306
R2652 VSS.n688 VSS.t126 0.227306
R2653 VSS.n688 VSS.t125 0.227306
R2654 VSS.n690 VSS.t127 0.227306
R2655 VSS.n690 VSS.t126 0.227306
R2656 VSS.n728 VSS.t50 0.227306
R2657 VSS.n728 VSS.t127 0.227306
R2658 VSS.n729 VSS.t51 0.227306
R2659 VSS.n729 VSS.t50 0.227306
R2660 VSS.n778 VSS.t52 0.227306
R2661 VSS.n778 VSS.t51 0.227306
R2662 VSS.n825 VSS.t53 0.227306
R2663 VSS.n825 VSS.t52 0.227306
R2664 VSS.n827 VSS.t54 0.227306
R2665 VSS.n827 VSS.t53 0.227306
R2666 VSS.n865 VSS.t55 0.227306
R2667 VSS.n865 VSS.t54 0.227306
R2668 VSS.n866 VSS.t56 0.227306
R2669 VSS.n866 VSS.t55 0.227306
R2670 VSS.n915 VSS.t57 0.227306
R2671 VSS.n915 VSS.t56 0.227306
R2672 VSS.n962 VSS.t231 0.227306
R2673 VSS.n962 VSS.t57 0.227306
R2674 VSS.n964 VSS.t232 0.227306
R2675 VSS.n964 VSS.t231 0.227306
R2676 VSS.n1002 VSS.t233 0.227306
R2677 VSS.n1002 VSS.t232 0.227306
R2678 VSS.n1003 VSS.t234 0.227306
R2679 VSS.n1003 VSS.t233 0.227306
R2680 VSS.n1052 VSS.t235 0.227306
R2681 VSS.n1052 VSS.t234 0.227306
R2682 VSS.n1099 VSS.t236 0.227306
R2683 VSS.n1099 VSS.t235 0.227306
R2684 VSS.n1101 VSS.t237 0.227306
R2685 VSS.n1101 VSS.t236 0.227306
R2686 VSS.n1716 VSS.n1715 0.2255
R2687 VSS.n7 VSS.n6 0.221
R2688 VSS.n1747 VSS.n1741 0.217461
R2689 VSS.n303 VSS.n302 0.210112
R2690 VSS.n1660 VSS.n76 0.210112
R2691 VSS.n1452 VSS.t59 0.20525
R2692 VSS.n1452 VSS.t31 0.20525
R2693 VSS.n1750 VSS.n1749 0.198607
R2694 VSS.n1730 VSS.n1729 0.192782
R2695 VSS.n1731 VSS.n1730 0.192775
R2696 VSS.n306 VSS.n305 0.191261
R2697 VSS.n316 VSS.n315 0.191261
R2698 VSS.n1292 VSS.n195 0.191261
R2699 VSS.n311 VSS.n310 0.191261
R2700 VSS.n359 VSS.n358 0.191261
R2701 VSS.n327 VSS.n326 0.191261
R2702 VSS.n451 VSS.n450 0.191261
R2703 VSS.n1749 VSS.n1745 0.186603
R2704 VSS.n1745 VSS.n1744 0.182489
R2705 VSS.n1710 VSS.n60 0.1805
R2706 VSS.n1710 VSS.n1709 0.1805
R2707 VSS.n1731 VSS.n1724 0.176318
R2708 VSS.n1729 VSS.n1728 0.173921
R2709 VSS.n141 VSS.t260 0.173667
R2710 VSS.n141 VSS.t261 0.173667
R2711 VSS.n1750 VSS.n1747 0.168096
R2712 VSS.n1814 VSS.n1813 0.163063
R2713 VSS.n1668 VSS.n1667 0.154786
R2714 VSS.n1701 VSS.n1675 0.154786
R2715 VSS.n1699 VSS.n1698 0.154786
R2716 VSS.n1698 VSS.n1697 0.154786
R2717 VSS.n1688 VSS.n1685 0.154786
R2718 VSS.n1720 VSS.n53 0.154786
R2719 VSS.n1734 VSS.n1722 0.154786
R2720 VSS.n1734 VSS.n1733 0.154786
R2721 VSS.n1809 VSS.n11 0.154786
R2722 VSS.n1742 VSS.n50 0.154786
R2723 VSS.n1756 VSS.n50 0.154786
R2724 VSS.n1759 VSS.n1758 0.154786
R2725 VSS.n1763 VSS.n1762 0.154786
R2726 VSS.n1765 VSS.n43 0.154786
R2727 VSS.n1769 VSS.n43 0.154786
R2728 VSS.n1772 VSS.n1771 0.154786
R2729 VSS.n1776 VSS.n1775 0.154786
R2730 VSS.n1287 VSS.n1286 0.154786
R2731 VSS.n471 VSS.n470 0.154786
R2732 VSS.n497 VSS.n496 0.154786
R2733 VSS.n519 VSS.n497 0.154786
R2734 VSS.n544 VSS.n521 0.154786
R2735 VSS.n569 VSS.n546 0.154786
R2736 VSS.n587 VSS.n571 0.154786
R2737 VSS.n588 VSS.n587 0.154786
R2738 VSS.n610 VSS.n609 0.154786
R2739 VSS.n634 VSS.n633 0.154786
R2740 VSS.n656 VSS.n634 0.154786
R2741 VSS.n681 VSS.n658 0.154786
R2742 VSS.n706 VSS.n683 0.154786
R2743 VSS.n724 VSS.n708 0.154786
R2744 VSS.n725 VSS.n724 0.154786
R2745 VSS.n747 VSS.n746 0.154786
R2746 VSS.n772 VSS.n771 0.154786
R2747 VSS.n796 VSS.n795 0.154786
R2748 VSS.n818 VSS.n796 0.154786
R2749 VSS.n843 VSS.n820 0.154786
R2750 VSS.n861 VSS.n845 0.154786
R2751 VSS.n862 VSS.n861 0.154786
R2752 VSS.n884 VSS.n883 0.154786
R2753 VSS.n909 VSS.n908 0.154786
R2754 VSS.n933 VSS.n932 0.154786
R2755 VSS.n955 VSS.n933 0.154786
R2756 VSS.n980 VSS.n957 0.154786
R2757 VSS.n998 VSS.n982 0.154786
R2758 VSS.n999 VSS.n998 0.154786
R2759 VSS.n1021 VSS.n1020 0.154786
R2760 VSS.n1046 VSS.n1045 0.154786
R2761 VSS.n1070 VSS.n1069 0.154786
R2762 VSS.n1092 VSS.n1070 0.154786
R2763 VSS.n1124 VSS.n1094 0.154786
R2764 VSS.n1129 VSS.n1128 0.154786
R2765 VSS.n319 VSS.n318 0.154786
R2766 VSS.n468 VSS.n467 0.154786
R2767 VSS.n492 VSS.n491 0.154786
R2768 VSS.n514 VSS.n492 0.154786
R2769 VSS.n539 VSS.n516 0.154786
R2770 VSS.n564 VSS.n541 0.154786
R2771 VSS.n584 VSS.n566 0.154786
R2772 VSS.n585 VSS.n584 0.154786
R2773 VSS.n605 VSS.n604 0.154786
R2774 VSS.n629 VSS.n628 0.154786
R2775 VSS.n651 VSS.n629 0.154786
R2776 VSS.n676 VSS.n653 0.154786
R2777 VSS.n701 VSS.n678 0.154786
R2778 VSS.n721 VSS.n703 0.154786
R2779 VSS.n722 VSS.n721 0.154786
R2780 VSS.n742 VSS.n741 0.154786
R2781 VSS.n767 VSS.n766 0.154786
R2782 VSS.n791 VSS.n790 0.154786
R2783 VSS.n813 VSS.n791 0.154786
R2784 VSS.n838 VSS.n815 0.154786
R2785 VSS.n858 VSS.n840 0.154786
R2786 VSS.n859 VSS.n858 0.154786
R2787 VSS.n879 VSS.n878 0.154786
R2788 VSS.n904 VSS.n903 0.154786
R2789 VSS.n928 VSS.n927 0.154786
R2790 VSS.n950 VSS.n928 0.154786
R2791 VSS.n975 VSS.n952 0.154786
R2792 VSS.n995 VSS.n977 0.154786
R2793 VSS.n996 VSS.n995 0.154786
R2794 VSS.n1016 VSS.n1015 0.154786
R2795 VSS.n1041 VSS.n1040 0.154786
R2796 VSS.n1065 VSS.n1064 0.154786
R2797 VSS.n1087 VSS.n1065 0.154786
R2798 VSS.n1116 VSS.n1089 0.154786
R2799 VSS.n1122 VSS.n1121 0.154786
R2800 VSS.n322 VSS.n321 0.154786
R2801 VSS.n475 VSS.n474 0.154786
R2802 VSS.n501 VSS.n500 0.154786
R2803 VSS.n523 VSS.n501 0.154786
R2804 VSS.n548 VSS.n525 0.154786
R2805 VSS.n573 VSS.n550 0.154786
R2806 VSS.n589 VSS.n575 0.154786
R2807 VSS.n590 VSS.n589 0.154786
R2808 VSS.n614 VSS.n613 0.154786
R2809 VSS.n638 VSS.n637 0.154786
R2810 VSS.n660 VSS.n638 0.154786
R2811 VSS.n685 VSS.n662 0.154786
R2812 VSS.n710 VSS.n687 0.154786
R2813 VSS.n726 VSS.n712 0.154786
R2814 VSS.n727 VSS.n726 0.154786
R2815 VSS.n751 VSS.n750 0.154786
R2816 VSS.n776 VSS.n775 0.154786
R2817 VSS.n800 VSS.n799 0.154786
R2818 VSS.n822 VSS.n800 0.154786
R2819 VSS.n847 VSS.n824 0.154786
R2820 VSS.n863 VSS.n849 0.154786
R2821 VSS.n864 VSS.n863 0.154786
R2822 VSS.n888 VSS.n887 0.154786
R2823 VSS.n913 VSS.n912 0.154786
R2824 VSS.n937 VSS.n936 0.154786
R2825 VSS.n959 VSS.n937 0.154786
R2826 VSS.n984 VSS.n961 0.154786
R2827 VSS.n1000 VSS.n986 0.154786
R2828 VSS.n1001 VSS.n1000 0.154786
R2829 VSS.n1025 VSS.n1024 0.154786
R2830 VSS.n1050 VSS.n1049 0.154786
R2831 VSS.n1074 VSS.n1073 0.154786
R2832 VSS.n1096 VSS.n1074 0.154786
R2833 VSS.n1131 VSS.n1098 0.154786
R2834 VSS.n1136 VSS.n1135 0.154786
R2835 VSS.n314 VSS.n313 0.154786
R2836 VSS.n464 VSS.n463 0.154786
R2837 VSS.n488 VSS.n487 0.154786
R2838 VSS.n510 VSS.n488 0.154786
R2839 VSS.n535 VSS.n512 0.154786
R2840 VSS.n560 VSS.n537 0.154786
R2841 VSS.n582 VSS.n562 0.154786
R2842 VSS.n583 VSS.n582 0.154786
R2843 VSS.n601 VSS.n600 0.154786
R2844 VSS.n625 VSS.n624 0.154786
R2845 VSS.n647 VSS.n625 0.154786
R2846 VSS.n672 VSS.n649 0.154786
R2847 VSS.n697 VSS.n674 0.154786
R2848 VSS.n719 VSS.n699 0.154786
R2849 VSS.n720 VSS.n719 0.154786
R2850 VSS.n738 VSS.n737 0.154786
R2851 VSS.n763 VSS.n762 0.154786
R2852 VSS.n787 VSS.n786 0.154786
R2853 VSS.n809 VSS.n787 0.154786
R2854 VSS.n834 VSS.n811 0.154786
R2855 VSS.n856 VSS.n836 0.154786
R2856 VSS.n857 VSS.n856 0.154786
R2857 VSS.n875 VSS.n874 0.154786
R2858 VSS.n900 VSS.n899 0.154786
R2859 VSS.n924 VSS.n923 0.154786
R2860 VSS.n946 VSS.n924 0.154786
R2861 VSS.n971 VSS.n948 0.154786
R2862 VSS.n993 VSS.n973 0.154786
R2863 VSS.n994 VSS.n993 0.154786
R2864 VSS.n1012 VSS.n1011 0.154786
R2865 VSS.n1037 VSS.n1036 0.154786
R2866 VSS.n1061 VSS.n1060 0.154786
R2867 VSS.n1083 VSS.n1061 0.154786
R2868 VSS.n1109 VSS.n1085 0.154786
R2869 VSS.n1114 VSS.n1113 0.154786
R2870 VSS.n356 VSS.n323 0.154786
R2871 VSS.n1279 VSS.n478 0.154786
R2872 VSS.n1277 VSS.n1276 0.154786
R2873 VSS.n1276 VSS.n480 0.154786
R2874 VSS.n1269 VSS.n1268 0.154786
R2875 VSS.n1266 VSS.n529 0.154786
R2876 VSS.n1259 VSS.n1258 0.154786
R2877 VSS.n1258 VSS.n1257 0.154786
R2878 VSS.n1250 VSS.n615 0.154786
R2879 VSS.n1248 VSS.n1247 0.154786
R2880 VSS.n1247 VSS.n617 0.154786
R2881 VSS.n1240 VSS.n1239 0.154786
R2882 VSS.n1237 VSS.n666 0.154786
R2883 VSS.n1230 VSS.n1229 0.154786
R2884 VSS.n1229 VSS.n1228 0.154786
R2885 VSS.n1221 VSS.n752 0.154786
R2886 VSS.n1219 VSS.n1218 0.154786
R2887 VSS.n1211 VSS.n801 0.154786
R2888 VSS.n1211 VSS.n1210 0.154786
R2889 VSS.n1208 VSS.n803 0.154786
R2890 VSS.n1201 VSS.n1200 0.154786
R2891 VSS.n1200 VSS.n1199 0.154786
R2892 VSS.n1192 VSS.n889 0.154786
R2893 VSS.n1190 VSS.n1189 0.154786
R2894 VSS.n1182 VSS.n938 0.154786
R2895 VSS.n1182 VSS.n1181 0.154786
R2896 VSS.n1179 VSS.n940 0.154786
R2897 VSS.n1172 VSS.n1171 0.154786
R2898 VSS.n1171 VSS.n1170 0.154786
R2899 VSS.n1163 VSS.n1026 0.154786
R2900 VSS.n1161 VSS.n1160 0.154786
R2901 VSS.n1153 VSS.n1075 0.154786
R2902 VSS.n1153 VSS.n1152 0.154786
R2903 VSS.n1150 VSS.n1077 0.154786
R2904 VSS.n1143 VSS.n1142 0.154786
R2905 VSS.n324 VSS.n309 0.154786
R2906 VSS.n460 VSS.n459 0.154786
R2907 VSS.n484 VSS.n483 0.154786
R2908 VSS.n506 VSS.n484 0.154786
R2909 VSS.n531 VSS.n508 0.154786
R2910 VSS.n556 VSS.n533 0.154786
R2911 VSS.n580 VSS.n558 0.154786
R2912 VSS.n581 VSS.n580 0.154786
R2913 VSS.n597 VSS.n596 0.154786
R2914 VSS.n621 VSS.n620 0.154786
R2915 VSS.n643 VSS.n621 0.154786
R2916 VSS.n668 VSS.n645 0.154786
R2917 VSS.n693 VSS.n670 0.154786
R2918 VSS.n717 VSS.n695 0.154786
R2919 VSS.n718 VSS.n717 0.154786
R2920 VSS.n734 VSS.n733 0.154786
R2921 VSS.n759 VSS.n758 0.154786
R2922 VSS.n783 VSS.n782 0.154786
R2923 VSS.n805 VSS.n783 0.154786
R2924 VSS.n830 VSS.n807 0.154786
R2925 VSS.n854 VSS.n832 0.154786
R2926 VSS.n855 VSS.n854 0.154786
R2927 VSS.n871 VSS.n870 0.154786
R2928 VSS.n896 VSS.n895 0.154786
R2929 VSS.n920 VSS.n919 0.154786
R2930 VSS.n942 VSS.n920 0.154786
R2931 VSS.n967 VSS.n944 0.154786
R2932 VSS.n991 VSS.n969 0.154786
R2933 VSS.n992 VSS.n991 0.154786
R2934 VSS.n1008 VSS.n1007 0.154786
R2935 VSS.n1033 VSS.n1032 0.154786
R2936 VSS.n1057 VSS.n1056 0.154786
R2937 VSS.n1079 VSS.n1057 0.154786
R2938 VSS.n1104 VSS.n1081 0.154786
R2939 VSS.n1107 VSS.n1106 0.154786
R2940 VSS.n1284 VSS.n453 0.154786
R2941 VSS.n1282 VSS.n1281 0.154786
R2942 VSS.n1274 VSS.n502 0.154786
R2943 VSS.n1274 VSS.n1273 0.154786
R2944 VSS.n1271 VSS.n504 0.154786
R2945 VSS.n1264 VSS.n1263 0.154786
R2946 VSS.n1261 VSS.n554 0.154786
R2947 VSS.n1255 VSS.n554 0.154786
R2948 VSS.n1253 VSS.n1252 0.154786
R2949 VSS.n1245 VSS.n639 0.154786
R2950 VSS.n1245 VSS.n1244 0.154786
R2951 VSS.n1242 VSS.n641 0.154786
R2952 VSS.n1235 VSS.n1234 0.154786
R2953 VSS.n1232 VSS.n691 0.154786
R2954 VSS.n1226 VSS.n691 0.154786
R2955 VSS.n1224 VSS.n1223 0.154786
R2956 VSS.n1216 VSS.n777 0.154786
R2957 VSS.n1214 VSS.n1213 0.154786
R2958 VSS.n1213 VSS.n779 0.154786
R2959 VSS.n1206 VSS.n1205 0.154786
R2960 VSS.n1203 VSS.n828 0.154786
R2961 VSS.n1197 VSS.n828 0.154786
R2962 VSS.n1195 VSS.n1194 0.154786
R2963 VSS.n1187 VSS.n914 0.154786
R2964 VSS.n1185 VSS.n1184 0.154786
R2965 VSS.n1184 VSS.n916 0.154786
R2966 VSS.n1177 VSS.n1176 0.154786
R2967 VSS.n1174 VSS.n965 0.154786
R2968 VSS.n1168 VSS.n965 0.154786
R2969 VSS.n1166 VSS.n1165 0.154786
R2970 VSS.n1158 VSS.n1051 0.154786
R2971 VSS.n1156 VSS.n1155 0.154786
R2972 VSS.n1155 VSS.n1053 0.154786
R2973 VSS.n1148 VSS.n1147 0.154786
R2974 VSS.n1145 VSS.n1102 0.154786
R2975 VSS.n1741 VSS.n13 0.151632
R2976 VSS.n1288 VSS.n1287 0.151186
R2977 VSS.n318 VSS.n317 0.151186
R2978 VSS.n321 VSS.n196 0.151186
R2979 VSS.n313 VSS.n312 0.151186
R2980 VSS.n357 VSS.n356 0.151186
R2981 VSS.n325 VSS.n324 0.151186
R2982 VSS.n453 VSS.n452 0.151186
R2983 VSS.n1721 VSS.n1720 0.150671
R2984 VSS.n794 VSS.n772 0.150671
R2985 VSS.n789 VSS.n767 0.150671
R2986 VSS.n798 VSS.n776 0.150671
R2987 VSS.n785 VSS.n763 0.150671
R2988 VSS.n1218 VSS.n755 0.150671
R2989 VSS.n781 VSS.n759 0.150671
R2990 VSS.n1216 VSS.n1215 0.150671
R2991 VSS.n1813 VSS.n4 0.150125
R2992 VSS.n1712 VSS.n1711 0.1499
R2993 VSS.n1777 VSS.n1776 0.149729
R2994 VSS.n658 VSS.n657 0.148614
R2995 VSS.n653 VSS.n652 0.148614
R2996 VSS.n662 VSS.n661 0.148614
R2997 VSS.n649 VSS.n648 0.148614
R2998 VSS.n1240 VSS.n664 0.148614
R2999 VSS.n645 VSS.n644 0.148614
R3000 VSS.n1243 VSS.n1242 0.148614
R3001 VSS.n1128 VSS.n1127 0.147071
R3002 VSS.n1121 VSS.n1120 0.147071
R3003 VSS.n1135 VSS.n1134 0.147071
R3004 VSS.n1113 VSS.n1112 0.147071
R3005 VSS.n1142 VSS.n1141 0.147071
R3006 VSS.n1106 VSS.n137 0.147071
R3007 VSS.n1102 VSS.n151 0.147071
R3008 VSS.n1758 VSS.n1757 0.1445
R3009 VSS.n1020 VSS.n1019 0.1445
R3010 VSS.n1015 VSS.n1014 0.1445
R3011 VSS.n1024 VSS.n1023 0.1445
R3012 VSS.n1011 VSS.n1010 0.1445
R3013 VSS.n1026 VSS.n990 0.1445
R3014 VSS.n1007 VSS.n1006 0.1445
R3015 VSS.n1167 VSS.n1166 0.1445
R3016 VSS.n931 VSS.n909 0.140386
R3017 VSS.n926 VSS.n904 0.140386
R3018 VSS.n935 VSS.n913 0.140386
R3019 VSS.n922 VSS.n900 0.140386
R3020 VSS.n1189 VSS.n892 0.140386
R3021 VSS.n918 VSS.n896 0.140386
R3022 VSS.n1187 VSS.n1186 0.140386
R3023 VSS.n521 VSS.n520 0.138329
R3024 VSS.n516 VSS.n515 0.138329
R3025 VSS.n525 VSS.n524 0.138329
R3026 VSS.n512 VSS.n511 0.138329
R3027 VSS.n1269 VSS.n527 0.138329
R3028 VSS.n508 VSS.n507 0.138329
R3029 VSS.n1272 VSS.n1271 0.138329
R3030 VSS.n570 VSS.n569 0.136271
R3031 VSS.n565 VSS.n564 0.136271
R3032 VSS.n574 VSS.n573 0.136271
R3033 VSS.n561 VSS.n560 0.136271
R3034 VSS.n577 VSS.n529 0.136271
R3035 VSS.n557 VSS.n556 0.136271
R3036 VSS.n1263 VSS.n1262 0.136271
R3037 VSS.n1728 VSS.n11 0.134214
R3038 VSS.n883 VSS.n882 0.134214
R3039 VSS.n878 VSS.n877 0.134214
R3040 VSS.n887 VSS.n886 0.134214
R3041 VSS.n874 VSS.n873 0.134214
R3042 VSS.n889 VSS.n853 0.134214
R3043 VSS.n870 VSS.n869 0.134214
R3044 VSS.n1196 VSS.n1195 0.134214
R3045 VSS.n1764 VSS.n1763 0.1301
R3046 VSS.n1068 VSS.n1046 0.1301
R3047 VSS.n1063 VSS.n1041 0.1301
R3048 VSS.n1072 VSS.n1050 0.1301
R3049 VSS.n1059 VSS.n1037 0.1301
R3050 VSS.n1160 VSS.n1029 0.1301
R3051 VSS.n1055 VSS.n1033 0.1301
R3052 VSS.n1158 VSS.n1157 0.1301
R3053 VSS.n1701 VSS.n1700 0.125986
R3054 VSS.n707 VSS.n706 0.125986
R3055 VSS.n702 VSS.n701 0.125986
R3056 VSS.n711 VSS.n710 0.125986
R3057 VSS.n698 VSS.n697 0.125986
R3058 VSS.n714 VSS.n666 0.125986
R3059 VSS.n694 VSS.n693 0.125986
R3060 VSS.n1234 VSS.n1233 0.125986
R3061 VSS.n1685 VSS.n1678 0.123929
R3062 VSS.n746 VSS.n745 0.123929
R3063 VSS.n741 VSS.n740 0.123929
R3064 VSS.n750 VSS.n749 0.123929
R3065 VSS.n737 VSS.n736 0.123929
R3066 VSS.n752 VSS.n716 0.123929
R3067 VSS.n733 VSS.n732 0.123929
R3068 VSS.n1225 VSS.n1224 0.123929
R3069 VSS.n1771 VSS.n1770 0.119814
R3070 VSS.n1094 VSS.n1093 0.119814
R3071 VSS.n1089 VSS.n1088 0.119814
R3072 VSS.n1098 VSS.n1097 0.119814
R3073 VSS.n1085 VSS.n1084 0.119814
R3074 VSS.n1151 VSS.n1150 0.119814
R3075 VSS.n1081 VSS.n1080 0.119814
R3076 VSS.n1148 VSS.n1100 0.119814
R3077 VSS.n844 VSS.n843 0.1157
R3078 VSS.n839 VSS.n838 0.1157
R3079 VSS.n848 VSS.n847 0.1157
R3080 VSS.n835 VSS.n834 0.1157
R3081 VSS.n851 VSS.n803 0.1157
R3082 VSS.n831 VSS.n830 0.1157
R3083 VSS.n1205 VSS.n1204 0.1157
R3084 VSS.n609 VSS.n608 0.113643
R3085 VSS.n604 VSS.n603 0.113643
R3086 VSS.n613 VSS.n612 0.113643
R3087 VSS.n600 VSS.n599 0.113643
R3088 VSS.n615 VSS.n579 0.113643
R3089 VSS.n596 VSS.n595 0.113643
R3090 VSS.n1254 VSS.n1253 0.113643
R3091 VSS.n495 VSS.n471 0.111586
R3092 VSS.n490 VSS.n468 0.111586
R3093 VSS.n499 VSS.n475 0.111586
R3094 VSS.n486 VSS.n464 0.111586
R3095 VSS.n1279 VSS.n1278 0.111586
R3096 VSS.n482 VSS.n460 0.111586
R3097 VSS.n1281 VSS.n456 0.111586
R3098 VSS.n957 VSS.n956 0.109529
R3099 VSS.n952 VSS.n951 0.109529
R3100 VSS.n961 VSS.n960 0.109529
R3101 VSS.n948 VSS.n947 0.109529
R3102 VSS.n1180 VSS.n1179 0.109529
R3103 VSS.n944 VSS.n943 0.109529
R3104 VSS.n1177 VSS.n963 0.109529
R3105 VSS.n981 VSS.n980 0.105414
R3106 VSS.n976 VSS.n975 0.105414
R3107 VSS.n985 VSS.n984 0.105414
R3108 VSS.n972 VSS.n971 0.105414
R3109 VSS.n988 VSS.n940 0.105414
R3110 VSS.n968 VSS.n967 0.105414
R3111 VSS.n1176 VSS.n1175 0.105414
R3112 VSS.n144 VSS.n143 0.1049
R3113 VSS.n470 VSS.n308 0.103357
R3114 VSS.n467 VSS.n466 0.103357
R3115 VSS.n474 VSS.n473 0.103357
R3116 VSS.n463 VSS.n462 0.103357
R3117 VSS.n478 VSS.n477 0.103357
R3118 VSS.n459 VSS.n458 0.103357
R3119 VSS.n1283 VSS.n1282 0.103357
R3120 VSS.n632 VSS.n610 0.1013
R3121 VSS.n627 VSS.n605 0.1013
R3122 VSS.n636 VSS.n614 0.1013
R3123 VSS.n623 VSS.n601 0.1013
R3124 VSS.n1250 VSS.n1249 0.1013
R3125 VSS.n619 VSS.n597 0.1013
R3126 VSS.n1252 VSS.n593 0.1013
R3127 VSS.n820 VSS.n819 0.0992429
R3128 VSS.n815 VSS.n814 0.0992429
R3129 VSS.n824 VSS.n823 0.0992429
R3130 VSS.n811 VSS.n810 0.0992429
R3131 VSS.n1209 VSS.n1208 0.0992429
R3132 VSS.n807 VSS.n806 0.0992429
R3133 VSS.n1206 VSS.n826 0.0992429
R3134 VSS.n1772 VSS.n40 0.0951286
R3135 VSS.n1125 VSS.n1124 0.0951286
R3136 VSS.n1117 VSS.n1116 0.0951286
R3137 VSS.n1132 VSS.n1131 0.0951286
R3138 VSS.n1110 VSS.n1109 0.0951286
R3139 VSS.n1138 VSS.n1077 0.0951286
R3140 VSS.n1105 VSS.n1104 0.0951286
R3141 VSS.n1147 VSS.n1146 0.0951286
R3142 VSS.n1688 VSS.n1687 0.0910143
R3143 VSS.n770 VSS.n747 0.0910143
R3144 VSS.n765 VSS.n742 0.0910143
R3145 VSS.n774 VSS.n751 0.0910143
R3146 VSS.n761 VSS.n738 0.0910143
R3147 VSS.n1221 VSS.n1220 0.0910143
R3148 VSS.n757 VSS.n734 0.0910143
R3149 VSS.n1223 VSS.n730 0.0910143
R3150 VSS.n447 VSS.n330 0.0905
R3151 VSS.n443 VSS.n330 0.0905
R3152 VSS.n443 VSS.n442 0.0905
R3153 VSS.n442 VSS.n441 0.0905
R3154 VSS.n441 VSS.n332 0.0905
R3155 VSS.n437 VSS.n332 0.0905
R3156 VSS.n437 VSS.n436 0.0905
R3157 VSS.n436 VSS.n435 0.0905
R3158 VSS.n435 VSS.n334 0.0905
R3159 VSS.n431 VSS.n334 0.0905
R3160 VSS.n431 VSS.n430 0.0905
R3161 VSS.n430 VSS.n429 0.0905
R3162 VSS.n429 VSS.n336 0.0905
R3163 VSS.n425 VSS.n336 0.0905
R3164 VSS.n425 VSS.n424 0.0905
R3165 VSS.n424 VSS.n423 0.0905
R3166 VSS.n423 VSS.n338 0.0905
R3167 VSS.n419 VSS.n338 0.0905
R3168 VSS.n419 VSS.n418 0.0905
R3169 VSS.n418 VSS.n340 0.0905
R3170 VSS.n414 VSS.n340 0.0905
R3171 VSS.n414 VSS.n413 0.0905
R3172 VSS.n413 VSS.n412 0.0905
R3173 VSS.n409 VSS.n408 0.0905
R3174 VSS.n408 VSS.n407 0.0905
R3175 VSS.n407 VSS.n344 0.0905
R3176 VSS.n403 VSS.n344 0.0905
R3177 VSS.n403 VSS.n402 0.0905
R3178 VSS.n402 VSS.n401 0.0905
R3179 VSS.n401 VSS.n346 0.0905
R3180 VSS.n397 VSS.n346 0.0905
R3181 VSS.n397 VSS.n396 0.0905
R3182 VSS.n396 VSS.n395 0.0905
R3183 VSS.n395 VSS.n348 0.0905
R3184 VSS.n391 VSS.n348 0.0905
R3185 VSS.n391 VSS.n390 0.0905
R3186 VSS.n390 VSS.n389 0.0905
R3187 VSS.n389 VSS.n350 0.0905
R3188 VSS.n385 VSS.n350 0.0905
R3189 VSS.n385 VSS.n384 0.0905
R3190 VSS.n384 VSS.n383 0.0905
R3191 VSS.n383 VSS.n352 0.0905
R3192 VSS.n379 VSS.n352 0.0905
R3193 VSS.n379 VSS.n378 0.0905
R3194 VSS.n378 VSS.n377 0.0905
R3195 VSS.n377 VSS.n354 0.0905
R3196 VSS.n373 VSS.n372 0.0905
R3197 VSS.n372 VSS.n371 0.0905
R3198 VSS.n371 VSS.n362 0.0905
R3199 VSS.n367 VSS.n362 0.0905
R3200 VSS.n367 VSS.n366 0.0905
R3201 VSS.n366 VSS.n365 0.0905
R3202 VSS.n365 VSS.n169 0.0905
R3203 VSS.n1356 VSS.n169 0.0905
R3204 VSS.n1356 VSS.n1355 0.0905
R3205 VSS.n1355 VSS.n1354 0.0905
R3206 VSS.n1354 VSS.n170 0.0905
R3207 VSS.n1350 VSS.n170 0.0905
R3208 VSS.n1350 VSS.n1349 0.0905
R3209 VSS.n1349 VSS.n1348 0.0905
R3210 VSS.n1348 VSS.n172 0.0905
R3211 VSS.n1344 VSS.n172 0.0905
R3212 VSS.n1344 VSS.n1343 0.0905
R3213 VSS.n1343 VSS.n1342 0.0905
R3214 VSS.n1342 VSS.n174 0.0905
R3215 VSS.n1337 VSS.n174 0.0905
R3216 VSS.n1337 VSS.n1336 0.0905
R3217 VSS.n1336 VSS.n1335 0.0905
R3218 VSS.n1335 VSS.n177 0.0905
R3219 VSS.n1331 VSS.n1330 0.0905
R3220 VSS.n1330 VSS.n1329 0.0905
R3221 VSS.n1329 VSS.n180 0.0905
R3222 VSS.n1325 VSS.n180 0.0905
R3223 VSS.n1325 VSS.n1324 0.0905
R3224 VSS.n1324 VSS.n1323 0.0905
R3225 VSS.n1323 VSS.n182 0.0905
R3226 VSS.n1319 VSS.n182 0.0905
R3227 VSS.n1319 VSS.n1318 0.0905
R3228 VSS.n1318 VSS.n1317 0.0905
R3229 VSS.n1317 VSS.n184 0.0905
R3230 VSS.n1313 VSS.n184 0.0905
R3231 VSS.n1313 VSS.n1312 0.0905
R3232 VSS.n1312 VSS.n1311 0.0905
R3233 VSS.n1311 VSS.n186 0.0905
R3234 VSS.n1307 VSS.n186 0.0905
R3235 VSS.n1307 VSS.n1306 0.0905
R3236 VSS.n1306 VSS.n1305 0.0905
R3237 VSS.n1305 VSS.n188 0.0905
R3238 VSS.n1301 VSS.n188 0.0905
R3239 VSS.n1301 VSS.n1300 0.0905
R3240 VSS.n1300 VSS.n1299 0.0905
R3241 VSS.n1299 VSS.n190 0.0905
R3242 VSS.n1295 VSS.n190 0.0905
R3243 VSS.n235 VSS.n192 0.0905
R3244 VSS.n238 VSS.n235 0.0905
R3245 VSS.n239 VSS.n238 0.0905
R3246 VSS.n240 VSS.n239 0.0905
R3247 VSS.n240 VSS.n233 0.0905
R3248 VSS.n244 VSS.n233 0.0905
R3249 VSS.n245 VSS.n244 0.0905
R3250 VSS.n245 VSS.n222 0.0905
R3251 VSS.n249 VSS.n222 0.0905
R3252 VSS.n250 VSS.n249 0.0905
R3253 VSS.n251 VSS.n250 0.0905
R3254 VSS.n251 VSS.n220 0.0905
R3255 VSS.n255 VSS.n220 0.0905
R3256 VSS.n256 VSS.n255 0.0905
R3257 VSS.n257 VSS.n256 0.0905
R3258 VSS.n257 VSS.n218 0.0905
R3259 VSS.n261 VSS.n218 0.0905
R3260 VSS.n262 VSS.n261 0.0905
R3261 VSS.n263 VSS.n262 0.0905
R3262 VSS.n263 VSS.n216 0.0905
R3263 VSS.n267 VSS.n216 0.0905
R3264 VSS.n268 VSS.n267 0.0905
R3265 VSS.n269 VSS.n268 0.0905
R3266 VSS.n273 VSS.n272 0.0905
R3267 VSS.n274 VSS.n273 0.0905
R3268 VSS.n274 VSS.n212 0.0905
R3269 VSS.n278 VSS.n212 0.0905
R3270 VSS.n279 VSS.n278 0.0905
R3271 VSS.n280 VSS.n279 0.0905
R3272 VSS.n280 VSS.n210 0.0905
R3273 VSS.n284 VSS.n210 0.0905
R3274 VSS.n285 VSS.n284 0.0905
R3275 VSS.n286 VSS.n285 0.0905
R3276 VSS.n286 VSS.n208 0.0905
R3277 VSS.n290 VSS.n208 0.0905
R3278 VSS.n291 VSS.n290 0.0905
R3279 VSS.n292 VSS.n291 0.0905
R3280 VSS.n292 VSS.n206 0.0905
R3281 VSS.n296 VSS.n206 0.0905
R3282 VSS.n297 VSS.n296 0.0905
R3283 VSS.n298 VSS.n297 0.0905
R3284 VSS.n298 VSS.n204 0.0905
R3285 VSS.n302 VSS.n204 0.0905
R3286 VSS.n1401 VSS.n154 0.0905
R3287 VSS.n1397 VSS.n154 0.0905
R3288 VSS.n1397 VSS.n1396 0.0905
R3289 VSS.n1396 VSS.n1395 0.0905
R3290 VSS.n1395 VSS.n156 0.0905
R3291 VSS.n1391 VSS.n156 0.0905
R3292 VSS.n1391 VSS.n1390 0.0905
R3293 VSS.n1390 VSS.n1389 0.0905
R3294 VSS.n1389 VSS.n158 0.0905
R3295 VSS.n1385 VSS.n158 0.0905
R3296 VSS.n1385 VSS.n1384 0.0905
R3297 VSS.n1384 VSS.n1383 0.0905
R3298 VSS.n1383 VSS.n160 0.0905
R3299 VSS.n1379 VSS.n160 0.0905
R3300 VSS.n1379 VSS.n1378 0.0905
R3301 VSS.n1378 VSS.n1377 0.0905
R3302 VSS.n1377 VSS.n162 0.0905
R3303 VSS.n1373 VSS.n162 0.0905
R3304 VSS.n1373 VSS.n1372 0.0905
R3305 VSS.n1372 VSS.n1367 0.0905
R3306 VSS.n1368 VSS.n1367 0.0905
R3307 VSS.n1368 VSS.n134 0.0905
R3308 VSS.n1411 VSS.n134 0.0905
R3309 VSS.n1415 VSS.n132 0.0905
R3310 VSS.n1416 VSS.n1415 0.0905
R3311 VSS.n1417 VSS.n1416 0.0905
R3312 VSS.n1417 VSS.n130 0.0905
R3313 VSS.n1421 VSS.n130 0.0905
R3314 VSS.n1422 VSS.n1421 0.0905
R3315 VSS.n1423 VSS.n1422 0.0905
R3316 VSS.n1423 VSS.n128 0.0905
R3317 VSS.n1427 VSS.n128 0.0905
R3318 VSS.n1428 VSS.n1427 0.0905
R3319 VSS.n1429 VSS.n1428 0.0905
R3320 VSS.n1429 VSS.n126 0.0905
R3321 VSS.n1433 VSS.n126 0.0905
R3322 VSS.n1434 VSS.n1433 0.0905
R3323 VSS.n1435 VSS.n1434 0.0905
R3324 VSS.n1435 VSS.n124 0.0905
R3325 VSS.n1439 VSS.n124 0.0905
R3326 VSS.n1440 VSS.n1439 0.0905
R3327 VSS.n1441 VSS.n1440 0.0905
R3328 VSS.n1441 VSS.n122 0.0905
R3329 VSS.n1497 VSS.n122 0.0905
R3330 VSS.n1498 VSS.n1497 0.0905
R3331 VSS.n1499 VSS.n1498 0.0905
R3332 VSS.n1503 VSS.n1502 0.0905
R3333 VSS.n1504 VSS.n1503 0.0905
R3334 VSS.n1504 VSS.n118 0.0905
R3335 VSS.n1508 VSS.n118 0.0905
R3336 VSS.n1509 VSS.n1508 0.0905
R3337 VSS.n1510 VSS.n1509 0.0905
R3338 VSS.n1510 VSS.n115 0.0905
R3339 VSS.n1515 VSS.n115 0.0905
R3340 VSS.n1516 VSS.n1515 0.0905
R3341 VSS.n1517 VSS.n1516 0.0905
R3342 VSS.n1517 VSS.n113 0.0905
R3343 VSS.n1521 VSS.n113 0.0905
R3344 VSS.n1522 VSS.n1521 0.0905
R3345 VSS.n1523 VSS.n1522 0.0905
R3346 VSS.n1523 VSS.n111 0.0905
R3347 VSS.n1527 VSS.n111 0.0905
R3348 VSS.n1528 VSS.n1527 0.0905
R3349 VSS.n1529 VSS.n1528 0.0905
R3350 VSS.n1529 VSS.n108 0.0905
R3351 VSS.n1534 VSS.n108 0.0905
R3352 VSS.n1535 VSS.n1534 0.0905
R3353 VSS.n1536 VSS.n1535 0.0905
R3354 VSS.n1536 VSS.n105 0.0905
R3355 VSS.n1585 VSS.n106 0.0905
R3356 VSS.n1581 VSS.n106 0.0905
R3357 VSS.n1581 VSS.n1580 0.0905
R3358 VSS.n1580 VSS.n1579 0.0905
R3359 VSS.n1579 VSS.n1540 0.0905
R3360 VSS.n1575 VSS.n1540 0.0905
R3361 VSS.n1575 VSS.n1574 0.0905
R3362 VSS.n1574 VSS.n1573 0.0905
R3363 VSS.n1573 VSS.n1542 0.0905
R3364 VSS.n1569 VSS.n1542 0.0905
R3365 VSS.n1569 VSS.n1568 0.0905
R3366 VSS.n1568 VSS.n1567 0.0905
R3367 VSS.n1567 VSS.n1544 0.0905
R3368 VSS.n1563 VSS.n1544 0.0905
R3369 VSS.n1563 VSS.n1562 0.0905
R3370 VSS.n1562 VSS.n1561 0.0905
R3371 VSS.n1561 VSS.n1546 0.0905
R3372 VSS.n1557 VSS.n1546 0.0905
R3373 VSS.n1557 VSS.n1556 0.0905
R3374 VSS.n1556 VSS.n1555 0.0905
R3375 VSS.n1555 VSS.n1548 0.0905
R3376 VSS.n1551 VSS.n1548 0.0905
R3377 VSS.n1551 VSS.n1550 0.0905
R3378 VSS.n1550 VSS.n101 0.0905
R3379 VSS.n1590 VSS.n99 0.0905
R3380 VSS.n1594 VSS.n99 0.0905
R3381 VSS.n1595 VSS.n1594 0.0905
R3382 VSS.n1596 VSS.n1595 0.0905
R3383 VSS.n1596 VSS.n97 0.0905
R3384 VSS.n1600 VSS.n97 0.0905
R3385 VSS.n1601 VSS.n1600 0.0905
R3386 VSS.n1601 VSS.n95 0.0905
R3387 VSS.n1605 VSS.n95 0.0905
R3388 VSS.n1606 VSS.n1605 0.0905
R3389 VSS.n1607 VSS.n1606 0.0905
R3390 VSS.n1607 VSS.n93 0.0905
R3391 VSS.n1611 VSS.n93 0.0905
R3392 VSS.n1612 VSS.n1611 0.0905
R3393 VSS.n1613 VSS.n1612 0.0905
R3394 VSS.n1613 VSS.n91 0.0905
R3395 VSS.n1617 VSS.n91 0.0905
R3396 VSS.n1618 VSS.n1617 0.0905
R3397 VSS.n1619 VSS.n1618 0.0905
R3398 VSS.n1619 VSS.n89 0.0905
R3399 VSS.n1623 VSS.n89 0.0905
R3400 VSS.n1624 VSS.n1623 0.0905
R3401 VSS.n1626 VSS.n1624 0.0905
R3402 VSS.n1630 VSS.n87 0.0905
R3403 VSS.n1631 VSS.n1630 0.0905
R3404 VSS.n1632 VSS.n1631 0.0905
R3405 VSS.n1632 VSS.n85 0.0905
R3406 VSS.n1636 VSS.n85 0.0905
R3407 VSS.n1637 VSS.n1636 0.0905
R3408 VSS.n1638 VSS.n1637 0.0905
R3409 VSS.n1638 VSS.n83 0.0905
R3410 VSS.n1642 VSS.n83 0.0905
R3411 VSS.n1643 VSS.n1642 0.0905
R3412 VSS.n1644 VSS.n1643 0.0905
R3413 VSS.n1644 VSS.n81 0.0905
R3414 VSS.n1648 VSS.n81 0.0905
R3415 VSS.n1649 VSS.n1648 0.0905
R3416 VSS.n1650 VSS.n1649 0.0905
R3417 VSS.n1650 VSS.n79 0.0905
R3418 VSS.n1654 VSS.n79 0.0905
R3419 VSS.n1655 VSS.n1654 0.0905
R3420 VSS.n1656 VSS.n1655 0.0905
R3421 VSS.n1656 VSS.n76 0.0905
R3422 VSS.n1364 VSS.n153 0.0900703
R3423 VSS.n329 VSS.n164 0.0900703
R3424 VSS.n1675 VSS.n67 0.0889571
R3425 VSS.n683 VSS.n682 0.0889571
R3426 VSS.n678 VSS.n677 0.0889571
R3427 VSS.n687 VSS.n686 0.0889571
R3428 VSS.n674 VSS.n673 0.0889571
R3429 VSS.n1238 VSS.n1237 0.0889571
R3430 VSS.n670 VSS.n669 0.0889571
R3431 VSS.n1235 VSS.n689 0.0889571
R3432 VSS.n1294 VSS.n192 0.0869
R3433 VSS.n1590 VSS.n1589 0.0869
R3434 VSS.n1762 VSS.n47 0.0848429
R3435 VSS.n1045 VSS.n1044 0.0848429
R3436 VSS.n1040 VSS.n1039 0.0848429
R3437 VSS.n1049 VSS.n1048 0.0848429
R3438 VSS.n1036 VSS.n1035 0.0848429
R3439 VSS.n1162 VSS.n1161 0.0848429
R3440 VSS.n1032 VSS.n1031 0.0848429
R3441 VSS.n1051 VSS.n1004 0.0848429
R3442 VSS.n907 VSS.n884 0.0807286
R3443 VSS.n902 VSS.n879 0.0807286
R3444 VSS.n911 VSS.n888 0.0807286
R3445 VSS.n898 VSS.n875 0.0807286
R3446 VSS.n1192 VSS.n1191 0.0807286
R3447 VSS.n894 VSS.n871 0.0807286
R3448 VSS.n1194 VSS.n867 0.0807286
R3449 VSS.n1288 VSS.n306 0.0796667
R3450 VSS.n317 VSS.n316 0.0796667
R3451 VSS.n196 VSS.n195 0.0796667
R3452 VSS.n312 VSS.n311 0.0796667
R3453 VSS.n358 VSS.n357 0.0796667
R3454 VSS.n326 VSS.n325 0.0796667
R3455 VSS.n452 VSS.n451 0.0796667
R3456 VSS.n546 VSS.n545 0.0786714
R3457 VSS.n541 VSS.n540 0.0786714
R3458 VSS.n550 VSS.n549 0.0786714
R3459 VSS.n537 VSS.n536 0.0786714
R3460 VSS.n1267 VSS.n1266 0.0786714
R3461 VSS.n533 VSS.n532 0.0786714
R3462 VSS.n1264 VSS.n552 0.0786714
R3463 VSS.n545 VSS.n544 0.0766143
R3464 VSS.n540 VSS.n539 0.0766143
R3465 VSS.n549 VSS.n548 0.0766143
R3466 VSS.n536 VSS.n535 0.0766143
R3467 VSS.n1268 VSS.n1267 0.0766143
R3468 VSS.n532 VSS.n531 0.0766143
R3469 VSS.n552 VSS.n504 0.0766143
R3470 VSS.n179 VSS.n177 0.07565
R3471 VSS.n1586 VSS.n105 0.07565
R3472 VSS.n908 VSS.n907 0.0745571
R3473 VSS.n903 VSS.n902 0.0745571
R3474 VSS.n912 VSS.n911 0.0745571
R3475 VSS.n899 VSS.n898 0.0745571
R3476 VSS.n1191 VSS.n1190 0.0745571
R3477 VSS.n895 VSS.n894 0.0745571
R3478 VSS.n914 VSS.n867 0.0745571
R3479 VSS.n448 VSS.n447 0.0707
R3480 VSS.n1402 VSS.n1401 0.0707
R3481 VSS.n1759 VSS.n47 0.0704429
R3482 VSS.n1044 VSS.n1021 0.0704429
R3483 VSS.n1039 VSS.n1016 0.0704429
R3484 VSS.n1048 VSS.n1025 0.0704429
R3485 VSS.n1035 VSS.n1012 0.0704429
R3486 VSS.n1163 VSS.n1162 0.0704429
R3487 VSS.n1031 VSS.n1008 0.0704429
R3488 VSS.n1165 VSS.n1004 0.0704429
R3489 VSS.n272 VSS.n214 0.06845
R3490 VSS.n1625 VSS.n87 0.06845
R3491 VSS.n1668 VSS.n67 0.0663286
R3492 VSS.n682 VSS.n681 0.0663286
R3493 VSS.n677 VSS.n676 0.0663286
R3494 VSS.n686 VSS.n685 0.0663286
R3495 VSS.n673 VSS.n672 0.0663286
R3496 VSS.n1239 VSS.n1238 0.0663286
R3497 VSS.n669 VSS.n668 0.0663286
R3498 VSS.n689 VSS.n641 0.0663286
R3499 VSS.n1687 VSS.n53 0.0642714
R3500 VSS.n771 VSS.n770 0.0642714
R3501 VSS.n766 VSS.n765 0.0642714
R3502 VSS.n775 VSS.n774 0.0642714
R3503 VSS.n762 VSS.n761 0.0642714
R3504 VSS.n1220 VSS.n1219 0.0642714
R3505 VSS.n758 VSS.n757 0.0642714
R3506 VSS.n777 VSS.n730 0.0642714
R3507 VSS.n339 VSS.n165 0.0605
R3508 VSS.n1361 VSS.n165 0.0605
R3509 VSS.n1361 VSS.n163 0.0605
R3510 VSS.n1513 VSS.n116 0.0605
R3511 VSS.n1365 VSS.n163 0.0605
R3512 VSS.n1366 VSS.n1365 0.0605
R3513 VSS.n1364 VSS.n1363 0.0605
R3514 VSS.n166 VSS.n116 0.0605
R3515 VSS.n1360 VSS.n166 0.0605
R3516 VSS.n1363 VSS.n1362 0.0605
R3517 VSS.n1362 VSS.n164 0.0605
R3518 VSS.n1360 VSS.n1359 0.0605
R3519 VSS.n1359 VSS.n1358 0.0605
R3520 VSS.n232 VSS.n231 0.0605
R3521 VSS.n231 VSS.n223 0.0605
R3522 VSS.n227 VSS.n223 0.0605
R3523 VSS.n1659 VSS.n77 0.0605
R3524 VSS.n227 VSS.n224 0.0605
R3525 VSS.n224 VSS.n96 0.0605
R3526 VSS.n1531 VSS.n109 0.0605
R3527 VSS.n226 VSS.n109 0.0605
R3528 VSS.n228 VSS.n77 0.0605
R3529 VSS.n229 VSS.n228 0.0605
R3530 VSS.n226 VSS.n225 0.0605
R3531 VSS.n225 VSS.n175 0.0605
R3532 VSS.n230 VSS.n229 0.0605
R3533 VSS.n230 VSS.n203 0.0605
R3534 VSS.n1340 VSS.n175 0.0605
R3535 VSS.n1775 VSS.n40 0.0601571
R3536 VSS.n1129 VSS.n1125 0.0601571
R3537 VSS.n1122 VSS.n1117 0.0601571
R3538 VSS.n1136 VSS.n1132 0.0601571
R3539 VSS.n1114 VSS.n1110 0.0601571
R3540 VSS.n1143 VSS.n1138 0.0601571
R3541 VSS.n1107 VSS.n1105 0.0601571
R3542 VSS.n1146 VSS.n1145 0.0601571
R3543 VSS.n361 VSS.n354 0.0572
R3544 VSS.n1499 VSS.n120 0.0572
R3545 VSS.n1733 VSS.n1724 0.0560429
R3546 VSS.n819 VSS.n818 0.0560429
R3547 VSS.n814 VSS.n813 0.0560429
R3548 VSS.n823 VSS.n822 0.0560429
R3549 VSS.n810 VSS.n809 0.0560429
R3550 VSS.n1210 VSS.n1209 0.0560429
R3551 VSS.n806 VSS.n805 0.0560429
R3552 VSS.n826 VSS.n779 0.0560429
R3553 VSS.n633 VSS.n632 0.0539857
R3554 VSS.n628 VSS.n627 0.0539857
R3555 VSS.n637 VSS.n636 0.0539857
R3556 VSS.n624 VSS.n623 0.0539857
R3557 VSS.n1249 VSS.n1248 0.0539857
R3558 VSS.n620 VSS.n619 0.0539857
R3559 VSS.n639 VSS.n593 0.0539857
R3560 VSS.n1365 VSS.n1364 0.0535114
R3561 VSS.n1365 VSS.n116 0.0535114
R3562 VSS.n1363 VSS.n163 0.0535114
R3563 VSS.n166 VSS.n163 0.0535114
R3564 VSS.n1362 VSS.n1361 0.0535114
R3565 VSS.n1361 VSS.n1360 0.0535114
R3566 VSS.n165 VSS.n164 0.0535114
R3567 VSS.n1359 VSS.n165 0.0535114
R3568 VSS.n224 VSS.n109 0.0535114
R3569 VSS.n224 VSS.n77 0.0535114
R3570 VSS.n227 VSS.n226 0.0535114
R3571 VSS.n228 VSS.n227 0.0535114
R3572 VSS.n225 VSS.n223 0.0535114
R3573 VSS.n229 VSS.n223 0.0535114
R3574 VSS.n231 VSS.n175 0.0535114
R3575 VSS.n231 VSS.n230 0.0535114
R3576 VSS.n409 VSS.n342 0.05225
R3577 VSS.n1410 VSS.n132 0.05225
R3578 VSS.n1286 VSS.n308 0.0519286
R3579 VSS.n466 VSS.n319 0.0519286
R3580 VSS.n473 VSS.n322 0.0519286
R3581 VSS.n462 VSS.n314 0.0519286
R3582 VSS.n477 VSS.n323 0.0519286
R3583 VSS.n458 VSS.n309 0.0519286
R3584 VSS.n1284 VSS.n1283 0.0519286
R3585 VSS.n1808 VSS.n13 0.0498714
R3586 VSS.n1744 VSS.n1742 0.0498714
R3587 VSS.n982 VSS.n981 0.0498714
R3588 VSS.n977 VSS.n976 0.0498714
R3589 VSS.n986 VSS.n985 0.0498714
R3590 VSS.n973 VSS.n972 0.0498714
R3591 VSS.n1172 VSS.n988 0.0498714
R3592 VSS.n969 VSS.n968 0.0498714
R3593 VSS.n1175 VSS.n1174 0.0498714
R3594 VSS.n956 VSS.n955 0.0457571
R3595 VSS.n951 VSS.n950 0.0457571
R3596 VSS.n960 VSS.n959 0.0457571
R3597 VSS.n947 VSS.n946 0.0457571
R3598 VSS.n1181 VSS.n1180 0.0457571
R3599 VSS.n943 VSS.n942 0.0457571
R3600 VSS.n963 VSS.n916 0.0457571
R3601 VSS.n496 VSS.n495 0.0437
R3602 VSS.n491 VSS.n490 0.0437
R3603 VSS.n500 VSS.n499 0.0437
R3604 VSS.n487 VSS.n486 0.0437
R3605 VSS.n1278 VSS.n1277 0.0437
R3606 VSS.n483 VSS.n482 0.0437
R3607 VSS.n502 VSS.n456 0.0437
R3608 VSS.n608 VSS.n588 0.0416429
R3609 VSS.n603 VSS.n585 0.0416429
R3610 VSS.n612 VSS.n590 0.0416429
R3611 VSS.n599 VSS.n583 0.0416429
R3612 VSS.n1257 VSS.n579 0.0416429
R3613 VSS.n595 VSS.n581 0.0416429
R3614 VSS.n1255 VSS.n1254 0.0416429
R3615 VSS.n845 VSS.n844 0.0395857
R3616 VSS.n840 VSS.n839 0.0395857
R3617 VSS.n849 VSS.n848 0.0395857
R3618 VSS.n836 VSS.n835 0.0395857
R3619 VSS.n1201 VSS.n851 0.0395857
R3620 VSS.n832 VSS.n831 0.0395857
R3621 VSS.n1204 VSS.n1203 0.0395857
R3622 VSS.n412 VSS.n342 0.03875
R3623 VSS.n1411 VSS.n1410 0.03875
R3624 VSS.n1770 VSS.n1769 0.0354714
R3625 VSS.n1093 VSS.n1092 0.0354714
R3626 VSS.n1088 VSS.n1087 0.0354714
R3627 VSS.n1097 VSS.n1096 0.0354714
R3628 VSS.n1084 VSS.n1083 0.0354714
R3629 VSS.n1152 VSS.n1151 0.0354714
R3630 VSS.n1080 VSS.n1079 0.0354714
R3631 VSS.n1100 VSS.n1053 0.0354714
R3632 VSS.n373 VSS.n361 0.0338
R3633 VSS.n1502 VSS.n120 0.0338
R3634 VSS.n1697 VSS.n1678 0.0313571
R3635 VSS.n1809 VSS.n1808 0.0313571
R3636 VSS.n745 VSS.n725 0.0313571
R3637 VSS.n740 VSS.n722 0.0313571
R3638 VSS.n749 VSS.n727 0.0313571
R3639 VSS.n736 VSS.n720 0.0313571
R3640 VSS.n1228 VSS.n716 0.0313571
R3641 VSS.n732 VSS.n718 0.0313571
R3642 VSS.n1226 VSS.n1225 0.0313571
R3643 VSS.n1700 VSS.n1699 0.0293
R3644 VSS.n708 VSS.n707 0.0293
R3645 VSS.n703 VSS.n702 0.0293
R3646 VSS.n712 VSS.n711 0.0293
R3647 VSS.n699 VSS.n698 0.0293
R3648 VSS.n1230 VSS.n714 0.0293
R3649 VSS.n695 VSS.n694 0.0293
R3650 VSS.n1233 VSS.n1232 0.0293
R3651 VSS.n1765 VSS.n1764 0.0251857
R3652 VSS.n1069 VSS.n1068 0.0251857
R3653 VSS.n1064 VSS.n1063 0.0251857
R3654 VSS.n1073 VSS.n1072 0.0251857
R3655 VSS.n1060 VSS.n1059 0.0251857
R3656 VSS.n1075 VSS.n1029 0.0251857
R3657 VSS.n1056 VSS.n1055 0.0251857
R3658 VSS.n1157 VSS.n1156 0.0251857
R3659 VSS.n1819 VSS.n1816 0.023
R3660 VSS.n1821 VSS.n1816 0.023
R3661 VSS.n1826 VSS.n1824 0.023
R3662 VSS.n1824 VSS.n1822 0.023
R3663 VSS.n1493 VSS.n1489 0.023
R3664 VSS.n1491 VSS.n1489 0.023
R3665 VSS.n269 VSS.n214 0.02255
R3666 VSS.n1626 VSS.n1625 0.02255
R3667 VSS.n882 VSS.n862 0.0210714
R3668 VSS.n877 VSS.n859 0.0210714
R3669 VSS.n886 VSS.n864 0.0210714
R3670 VSS.n873 VSS.n857 0.0210714
R3671 VSS.n1199 VSS.n853 0.0210714
R3672 VSS.n869 VSS.n855 0.0210714
R3673 VSS.n1197 VSS.n1196 0.0210714
R3674 VSS.n571 VSS.n570 0.0190143
R3675 VSS.n566 VSS.n565 0.0190143
R3676 VSS.n575 VSS.n574 0.0190143
R3677 VSS.n562 VSS.n561 0.0190143
R3678 VSS.n1259 VSS.n577 0.0190143
R3679 VSS.n558 VSS.n557 0.0190143
R3680 VSS.n1262 VSS.n1261 0.0190143
R3681 VSS.n520 VSS.n519 0.0169571
R3682 VSS.n515 VSS.n514 0.0169571
R3683 VSS.n524 VSS.n523 0.0169571
R3684 VSS.n511 VSS.n510 0.0169571
R3685 VSS.n527 VSS.n480 0.0169571
R3686 VSS.n507 VSS.n506 0.0169571
R3687 VSS.n1273 VSS.n1272 0.0169571
R3688 VSS.n1331 VSS.n179 0.01535
R3689 VSS.n1586 VSS.n1585 0.01535
R3690 VSS.n932 VSS.n931 0.0149
R3691 VSS.n927 VSS.n926 0.0149
R3692 VSS.n936 VSS.n935 0.0149
R3693 VSS.n923 VSS.n922 0.0149
R3694 VSS.n938 VSS.n892 0.0149
R3695 VSS.n919 VSS.n918 0.0149
R3696 VSS.n1186 VSS.n1185 0.0149
R3697 VSS.n446 VSS.n329 0.0124968
R3698 VSS.n1400 VSS.n153 0.0124968
R3699 VSS.n1815 VSS.n1814 0.0123125
R3700 VSS.n7 VSS.n5 0.01175
R3701 VSS.n1757 VSS.n1756 0.0107857
R3702 VSS.n1289 VSS.n305 0.0107857
R3703 VSS.n1019 VSS.n999 0.0107857
R3704 VSS.n148 VSS.n75 0.0107857
R3705 VSS.n315 VSS.n201 0.0107857
R3706 VSS.n1014 VSS.n996 0.0107857
R3707 VSS.n1118 VSS.n140 0.0107857
R3708 VSS.n1292 VSS.n1291 0.0107857
R3709 VSS.n1023 VSS.n1001 0.0107857
R3710 VSS.n149 VSS.n102 0.0107857
R3711 VSS.n310 VSS.n200 0.0107857
R3712 VSS.n1010 VSS.n994 0.0107857
R3713 VSS.n139 VSS.n104 0.0107857
R3714 VSS.n359 VSS.n199 0.0107857
R3715 VSS.n1170 VSS.n990 0.0107857
R3716 VSS.n1139 VSS.n150 0.0107857
R3717 VSS.n327 VSS.n198 0.0107857
R3718 VSS.n1006 VSS.n992 0.0107857
R3719 VSS.n1408 VSS.n1407 0.0107857
R3720 VSS.n450 VSS.n197 0.0107857
R3721 VSS.n1168 VSS.n1167 0.0107857
R3722 VSS.n1405 VSS.n1404 0.0107857
R3723 VSS.n1818 VSS.n1817 0.0105
R3724 VSS.n1820 VSS.n1818 0.0105
R3725 VSS.n1827 VSS.n1823 0.0105
R3726 VSS.n1825 VSS.n1823 0.0105
R3727 VSS.n1490 VSS.n2 0.0105
R3728 VSS.n1492 VSS.n1490 0.0105
R3729 VSS.n1352 VSS.n1351 0.00901064
R3730 VSS.n1351 VSS.n171 0.00901064
R3731 VSS.n1347 VSS.n171 0.00901064
R3732 VSS.n1347 VSS.n1346 0.00901064
R3733 VSS.n1520 VSS.n1519 0.00901064
R3734 VSS.n1520 VSS.n112 0.00901064
R3735 VSS.n1524 VSS.n112 0.00901064
R3736 VSS.n1525 VSS.n1524 0.00901064
R3737 VSS.n1127 VSS.n148 0.00821429
R3738 VSS.n1120 VSS.n140 0.00821429
R3739 VSS.n1134 VSS.n149 0.00821429
R3740 VSS.n1112 VSS.n139 0.00821429
R3741 VSS.n1141 VSS.n150 0.00821429
R3742 VSS.n1407 VSS.n137 0.00821429
R3743 VSS.n1405 VSS.n151 0.00821429
R3744 VSS.n657 VSS.n656 0.00667143
R3745 VSS.n652 VSS.n651 0.00667143
R3746 VSS.n661 VSS.n660 0.00667143
R3747 VSS.n648 VSS.n647 0.00667143
R3748 VSS.n664 VSS.n617 0.00667143
R3749 VSS.n644 VSS.n643 0.00667143
R3750 VSS.n1244 VSS.n1243 0.00667143
R3751 VSS.n1346 VSS.n1345 0.00654389
R3752 VSS.n1526 VSS.n1525 0.00654389
R3753 VSS.n1722 VSS.n1721 0.00461429
R3754 VSS.n795 VSS.n794 0.00461429
R3755 VSS.n790 VSS.n789 0.00461429
R3756 VSS.n799 VSS.n798 0.00461429
R3757 VSS.n786 VSS.n785 0.00461429
R3758 VSS.n801 VSS.n755 0.00461429
R3759 VSS.n782 VSS.n781 0.00461429
R3760 VSS.n1215 VSS.n1214 0.00461429
R3761 VSS VSS.n1830 0.00425
R3762 VSS.n1353 VSS.n1352 0.00422224
R3763 VSS.n1519 VSS.n1518 0.00422224
R3764 VSS.n1289 VSS.n1288 0.0041
R3765 VSS.n317 VSS.n201 0.0041
R3766 VSS.n1291 VSS.n196 0.0041
R3767 VSS.n312 VSS.n200 0.0041
R3768 VSS.n357 VSS.n199 0.0041
R3769 VSS.n325 VSS.n198 0.0041
R3770 VSS.n1295 VSS.n1294 0.0041
R3771 VSS.n452 VSS.n197 0.0041
R3772 VSS.n1589 VSS.n101 0.0041
R3773 VSS.n1345 VSS.n173 0.00175549
R3774 VSS.n1341 VSS.n173 0.00175549
R3775 VSS.n1339 VSS.n1338 0.00175549
R3776 VSS.n1338 VSS.n176 0.00175549
R3777 VSS.n1334 VSS.n176 0.00175549
R3778 VSS.n1334 VSS.n1333 0.00175549
R3779 VSS.n1333 VSS.n1332 0.00175549
R3780 VSS.n1332 VSS.n178 0.00175549
R3781 VSS.n1328 VSS.n178 0.00175549
R3782 VSS.n1328 VSS.n1327 0.00175549
R3783 VSS.n1327 VSS.n1326 0.00175549
R3784 VSS.n1326 VSS.n181 0.00175549
R3785 VSS.n1322 VSS.n181 0.00175549
R3786 VSS.n1322 VSS.n1321 0.00175549
R3787 VSS.n1321 VSS.n1320 0.00175549
R3788 VSS.n1320 VSS.n183 0.00175549
R3789 VSS.n1316 VSS.n183 0.00175549
R3790 VSS.n1316 VSS.n1315 0.00175549
R3791 VSS.n1315 VSS.n1314 0.00175549
R3792 VSS.n1314 VSS.n185 0.00175549
R3793 VSS.n1310 VSS.n185 0.00175549
R3794 VSS.n1310 VSS.n1309 0.00175549
R3795 VSS.n1309 VSS.n1308 0.00175549
R3796 VSS.n1308 VSS.n187 0.00175549
R3797 VSS.n1304 VSS.n187 0.00175549
R3798 VSS.n1304 VSS.n1303 0.00175549
R3799 VSS.n1303 VSS.n1302 0.00175549
R3800 VSS.n1302 VSS.n189 0.00175549
R3801 VSS.n1298 VSS.n189 0.00175549
R3802 VSS.n1298 VSS.n1297 0.00175549
R3803 VSS.n1297 VSS.n1296 0.00175549
R3804 VSS.n1296 VSS.n191 0.00175549
R3805 VSS.n236 VSS.n191 0.00175549
R3806 VSS.n237 VSS.n236 0.00175549
R3807 VSS.n237 VSS.n234 0.00175549
R3808 VSS.n241 VSS.n234 0.00175549
R3809 VSS.n242 VSS.n241 0.00175549
R3810 VSS.n243 VSS.n242 0.00175549
R3811 VSS.n247 VSS.n246 0.00175549
R3812 VSS.n248 VSS.n247 0.00175549
R3813 VSS.n248 VSS.n221 0.00175549
R3814 VSS.n252 VSS.n221 0.00175549
R3815 VSS.n253 VSS.n252 0.00175549
R3816 VSS.n254 VSS.n253 0.00175549
R3817 VSS.n254 VSS.n219 0.00175549
R3818 VSS.n258 VSS.n219 0.00175549
R3819 VSS.n259 VSS.n258 0.00175549
R3820 VSS.n260 VSS.n259 0.00175549
R3821 VSS.n260 VSS.n217 0.00175549
R3822 VSS.n264 VSS.n217 0.00175549
R3823 VSS.n265 VSS.n264 0.00175549
R3824 VSS.n266 VSS.n265 0.00175549
R3825 VSS.n266 VSS.n215 0.00175549
R3826 VSS.n270 VSS.n215 0.00175549
R3827 VSS.n271 VSS.n270 0.00175549
R3828 VSS.n271 VSS.n213 0.00175549
R3829 VSS.n275 VSS.n213 0.00175549
R3830 VSS.n276 VSS.n275 0.00175549
R3831 VSS.n277 VSS.n276 0.00175549
R3832 VSS.n277 VSS.n211 0.00175549
R3833 VSS.n281 VSS.n211 0.00175549
R3834 VSS.n282 VSS.n281 0.00175549
R3835 VSS.n283 VSS.n282 0.00175549
R3836 VSS.n283 VSS.n209 0.00175549
R3837 VSS.n287 VSS.n209 0.00175549
R3838 VSS.n288 VSS.n287 0.00175549
R3839 VSS.n289 VSS.n288 0.00175549
R3840 VSS.n289 VSS.n207 0.00175549
R3841 VSS.n293 VSS.n207 0.00175549
R3842 VSS.n294 VSS.n293 0.00175549
R3843 VSS.n295 VSS.n294 0.00175549
R3844 VSS.n295 VSS.n205 0.00175549
R3845 VSS.n299 VSS.n205 0.00175549
R3846 VSS.n300 VSS.n299 0.00175549
R3847 VSS.n301 VSS.n300 0.00175549
R3848 VSS.n446 VSS.n445 0.00175549
R3849 VSS.n445 VSS.n444 0.00175549
R3850 VSS.n444 VSS.n331 0.00175549
R3851 VSS.n440 VSS.n331 0.00175549
R3852 VSS.n440 VSS.n439 0.00175549
R3853 VSS.n439 VSS.n438 0.00175549
R3854 VSS.n438 VSS.n333 0.00175549
R3855 VSS.n434 VSS.n333 0.00175549
R3856 VSS.n434 VSS.n433 0.00175549
R3857 VSS.n433 VSS.n432 0.00175549
R3858 VSS.n432 VSS.n335 0.00175549
R3859 VSS.n428 VSS.n335 0.00175549
R3860 VSS.n428 VSS.n427 0.00175549
R3861 VSS.n427 VSS.n426 0.00175549
R3862 VSS.n426 VSS.n337 0.00175549
R3863 VSS.n422 VSS.n337 0.00175549
R3864 VSS.n422 VSS.n421 0.00175549
R3865 VSS.n421 VSS.n420 0.00175549
R3866 VSS.n417 VSS.n416 0.00175549
R3867 VSS.n416 VSS.n415 0.00175549
R3868 VSS.n415 VSS.n341 0.00175549
R3869 VSS.n411 VSS.n341 0.00175549
R3870 VSS.n411 VSS.n410 0.00175549
R3871 VSS.n410 VSS.n343 0.00175549
R3872 VSS.n406 VSS.n343 0.00175549
R3873 VSS.n406 VSS.n405 0.00175549
R3874 VSS.n405 VSS.n404 0.00175549
R3875 VSS.n404 VSS.n345 0.00175549
R3876 VSS.n400 VSS.n345 0.00175549
R3877 VSS.n400 VSS.n399 0.00175549
R3878 VSS.n399 VSS.n398 0.00175549
R3879 VSS.n398 VSS.n347 0.00175549
R3880 VSS.n394 VSS.n347 0.00175549
R3881 VSS.n394 VSS.n393 0.00175549
R3882 VSS.n393 VSS.n392 0.00175549
R3883 VSS.n392 VSS.n349 0.00175549
R3884 VSS.n388 VSS.n349 0.00175549
R3885 VSS.n388 VSS.n387 0.00175549
R3886 VSS.n387 VSS.n386 0.00175549
R3887 VSS.n386 VSS.n351 0.00175549
R3888 VSS.n382 VSS.n351 0.00175549
R3889 VSS.n382 VSS.n381 0.00175549
R3890 VSS.n381 VSS.n380 0.00175549
R3891 VSS.n380 VSS.n353 0.00175549
R3892 VSS.n376 VSS.n353 0.00175549
R3893 VSS.n376 VSS.n375 0.00175549
R3894 VSS.n375 VSS.n374 0.00175549
R3895 VSS.n374 VSS.n355 0.00175549
R3896 VSS.n370 VSS.n355 0.00175549
R3897 VSS.n370 VSS.n369 0.00175549
R3898 VSS.n369 VSS.n368 0.00175549
R3899 VSS.n368 VSS.n363 0.00175549
R3900 VSS.n364 VSS.n363 0.00175549
R3901 VSS.n364 VSS.n167 0.00175549
R3902 VSS.n1357 VSS.n168 0.00175549
R3903 VSS.n1353 VSS.n168 0.00175549
R3904 VSS.n1526 VSS.n110 0.00175549
R3905 VSS.n1530 VSS.n110 0.00175549
R3906 VSS.n1533 VSS.n1532 0.00175549
R3907 VSS.n1533 VSS.n107 0.00175549
R3908 VSS.n1537 VSS.n107 0.00175549
R3909 VSS.n1538 VSS.n1537 0.00175549
R3910 VSS.n1584 VSS.n1538 0.00175549
R3911 VSS.n1584 VSS.n1583 0.00175549
R3912 VSS.n1583 VSS.n1582 0.00175549
R3913 VSS.n1582 VSS.n1539 0.00175549
R3914 VSS.n1578 VSS.n1539 0.00175549
R3915 VSS.n1578 VSS.n1577 0.00175549
R3916 VSS.n1577 VSS.n1576 0.00175549
R3917 VSS.n1576 VSS.n1541 0.00175549
R3918 VSS.n1572 VSS.n1541 0.00175549
R3919 VSS.n1572 VSS.n1571 0.00175549
R3920 VSS.n1571 VSS.n1570 0.00175549
R3921 VSS.n1570 VSS.n1543 0.00175549
R3922 VSS.n1566 VSS.n1543 0.00175549
R3923 VSS.n1566 VSS.n1565 0.00175549
R3924 VSS.n1565 VSS.n1564 0.00175549
R3925 VSS.n1564 VSS.n1545 0.00175549
R3926 VSS.n1560 VSS.n1545 0.00175549
R3927 VSS.n1560 VSS.n1559 0.00175549
R3928 VSS.n1559 VSS.n1558 0.00175549
R3929 VSS.n1558 VSS.n1547 0.00175549
R3930 VSS.n1554 VSS.n1547 0.00175549
R3931 VSS.n1554 VSS.n1553 0.00175549
R3932 VSS.n1553 VSS.n1552 0.00175549
R3933 VSS.n1552 VSS.n1549 0.00175549
R3934 VSS.n1549 VSS.n100 0.00175549
R3935 VSS.n1591 VSS.n100 0.00175549
R3936 VSS.n1592 VSS.n1591 0.00175549
R3937 VSS.n1593 VSS.n1592 0.00175549
R3938 VSS.n1593 VSS.n98 0.00175549
R3939 VSS.n1597 VSS.n98 0.00175549
R3940 VSS.n1598 VSS.n1597 0.00175549
R3941 VSS.n1599 VSS.n1598 0.00175549
R3942 VSS.n1603 VSS.n1602 0.00175549
R3943 VSS.n1604 VSS.n1603 0.00175549
R3944 VSS.n1604 VSS.n94 0.00175549
R3945 VSS.n1608 VSS.n94 0.00175549
R3946 VSS.n1609 VSS.n1608 0.00175549
R3947 VSS.n1610 VSS.n1609 0.00175549
R3948 VSS.n1610 VSS.n92 0.00175549
R3949 VSS.n1614 VSS.n92 0.00175549
R3950 VSS.n1615 VSS.n1614 0.00175549
R3951 VSS.n1616 VSS.n1615 0.00175549
R3952 VSS.n1616 VSS.n90 0.00175549
R3953 VSS.n1620 VSS.n90 0.00175549
R3954 VSS.n1621 VSS.n1620 0.00175549
R3955 VSS.n1622 VSS.n1621 0.00175549
R3956 VSS.n1622 VSS.n88 0.00175549
R3957 VSS.n1627 VSS.n88 0.00175549
R3958 VSS.n1628 VSS.n1627 0.00175549
R3959 VSS.n1629 VSS.n1628 0.00175549
R3960 VSS.n1629 VSS.n86 0.00175549
R3961 VSS.n1633 VSS.n86 0.00175549
R3962 VSS.n1634 VSS.n1633 0.00175549
R3963 VSS.n1635 VSS.n1634 0.00175549
R3964 VSS.n1635 VSS.n84 0.00175549
R3965 VSS.n1639 VSS.n84 0.00175549
R3966 VSS.n1640 VSS.n1639 0.00175549
R3967 VSS.n1641 VSS.n1640 0.00175549
R3968 VSS.n1641 VSS.n82 0.00175549
R3969 VSS.n1645 VSS.n82 0.00175549
R3970 VSS.n1646 VSS.n1645 0.00175549
R3971 VSS.n1647 VSS.n1646 0.00175549
R3972 VSS.n1647 VSS.n80 0.00175549
R3973 VSS.n1651 VSS.n80 0.00175549
R3974 VSS.n1652 VSS.n1651 0.00175549
R3975 VSS.n1653 VSS.n1652 0.00175549
R3976 VSS.n1653 VSS.n78 0.00175549
R3977 VSS.n1657 VSS.n78 0.00175549
R3978 VSS.n1658 VSS.n1657 0.00175549
R3979 VSS.n1400 VSS.n1399 0.00175549
R3980 VSS.n1399 VSS.n1398 0.00175549
R3981 VSS.n1398 VSS.n155 0.00175549
R3982 VSS.n1394 VSS.n155 0.00175549
R3983 VSS.n1394 VSS.n1393 0.00175549
R3984 VSS.n1393 VSS.n1392 0.00175549
R3985 VSS.n1392 VSS.n157 0.00175549
R3986 VSS.n1388 VSS.n157 0.00175549
R3987 VSS.n1388 VSS.n1387 0.00175549
R3988 VSS.n1387 VSS.n1386 0.00175549
R3989 VSS.n1386 VSS.n159 0.00175549
R3990 VSS.n1382 VSS.n159 0.00175549
R3991 VSS.n1382 VSS.n1381 0.00175549
R3992 VSS.n1381 VSS.n1380 0.00175549
R3993 VSS.n1380 VSS.n161 0.00175549
R3994 VSS.n1376 VSS.n161 0.00175549
R3995 VSS.n1376 VSS.n1375 0.00175549
R3996 VSS.n1375 VSS.n1374 0.00175549
R3997 VSS.n1371 VSS.n1370 0.00175549
R3998 VSS.n1370 VSS.n1369 0.00175549
R3999 VSS.n1369 VSS.n133 0.00175549
R4000 VSS.n1412 VSS.n133 0.00175549
R4001 VSS.n1413 VSS.n1412 0.00175549
R4002 VSS.n1414 VSS.n1413 0.00175549
R4003 VSS.n1414 VSS.n131 0.00175549
R4004 VSS.n1418 VSS.n131 0.00175549
R4005 VSS.n1419 VSS.n1418 0.00175549
R4006 VSS.n1420 VSS.n1419 0.00175549
R4007 VSS.n1420 VSS.n129 0.00175549
R4008 VSS.n1424 VSS.n129 0.00175549
R4009 VSS.n1425 VSS.n1424 0.00175549
R4010 VSS.n1426 VSS.n1425 0.00175549
R4011 VSS.n1426 VSS.n127 0.00175549
R4012 VSS.n1430 VSS.n127 0.00175549
R4013 VSS.n1431 VSS.n1430 0.00175549
R4014 VSS.n1432 VSS.n1431 0.00175549
R4015 VSS.n1432 VSS.n125 0.00175549
R4016 VSS.n1436 VSS.n125 0.00175549
R4017 VSS.n1437 VSS.n1436 0.00175549
R4018 VSS.n1438 VSS.n1437 0.00175549
R4019 VSS.n1438 VSS.n123 0.00175549
R4020 VSS.n1442 VSS.n123 0.00175549
R4021 VSS.n1443 VSS.n1442 0.00175549
R4022 VSS.n1496 VSS.n121 0.00175549
R4023 VSS.n1500 VSS.n121 0.00175549
R4024 VSS.n1501 VSS.n1500 0.00175549
R4025 VSS.n1501 VSS.n119 0.00175549
R4026 VSS.n1505 VSS.n119 0.00175549
R4027 VSS.n1506 VSS.n1505 0.00175549
R4028 VSS.n1507 VSS.n1506 0.00175549
R4029 VSS.n1507 VSS.n117 0.00175549
R4030 VSS.n1511 VSS.n117 0.00175549
R4031 VSS.n1512 VSS.n1511 0.00175549
R4032 VSS.n1514 VSS.n114 0.00175549
R4033 VSS.n1518 VSS.n114 0.00175549
R4034 VSS.n1365 VSS.t273 0.00173626
R4035 VSS.n163 VSS.t272 0.00173626
R4036 VSS.n1361 VSS.t271 0.00173626
R4037 VSS.n165 VSS.t270 0.00173626
R4038 VSS.n224 VSS.t267 0.00173626
R4039 VSS.n227 VSS.t266 0.00173626
R4040 VSS.n223 VSS.t265 0.00173626
R4041 VSS.n231 VSS.t264 0.00173626
R4042 VSS.n232 VSS.t263 0.00173626
R4043 VSS.n339 VSS.t269 0.00173626
R4044 VSS.n96 VSS.t268 0.00173626
R4045 VSS.n1366 VSS.t274 0.00173626
R4046 VSS.n243 VSS.n232 0.00173038
R4047 VSS.n1599 VSS.n96 0.00173038
R4048 VSS.n1495 VSS.n1443 0.00173038
R4049 VSS.n1341 VSS.n1340 0.00132862
R4050 VSS.n417 VSS.n339 0.00132862
R4051 VSS.n1358 VSS.n167 0.00132862
R4052 VSS.n1531 VSS.n1530 0.00132862
R4053 VSS.n1371 VSS.n1366 0.00132862
R4054 VSS.n1513 VSS.n1512 0.00132862
R4055 VSS.n1340 VSS.n1339 0.000926868
R4056 VSS.n420 VSS.n339 0.000926868
R4057 VSS.n1358 VSS.n1357 0.000926868
R4058 VSS.n1532 VSS.n1531 0.000926868
R4059 VSS.n1374 VSS.n1366 0.000926868
R4060 VSS.n1514 VSS.n1513 0.000926868
R4061 VSS.n301 VSS.n203 0.000876648
R4062 VSS.n1659 VSS.n1658 0.000876648
R4063 VSS.n246 VSS.n232 0.00052511
R4064 VSS.n1602 VSS.n96 0.00052511
R4065 VSS.n1496 VSS.n1495 0.00052511
R4066 a_34356_n18934.t0 a_34356_n18934.t1 23.3323
R4067 a_9124_n19574.t1 a_9124_n19574.n0 22.2059
R4068 a_9124_n19574.n0 a_9124_n19574.t2 18.7816
R4069 a_9124_n19574.n0 a_9124_n19574.t0 15.4044
R4070 a_31212_n18414.t0 a_31212_n18414.t1 23.3323
R4071 a_34356_n17894.t0 a_34356_n17894.t1 23.3323
R4072 a_31212_n17374.t0 a_31212_n17374.t1 23.3323
R4073 a_34356_n16854.t0 a_34356_n16854.t1 23.3323
R4074 a_31212_n16334.t0 a_31212_n16334.t1 23.3323
R4075 a_13714_n17054.n0 a_13714_n17054.t3 0.2735
R4076 a_13714_n17054.t5 a_13714_n17054.n0 0.2735
R4077 a_13714_n17054.n0 a_13714_n17054.n2 10.61
R4078 a_13714_n17054.n2 a_13714_n17054.n5 5.11025
R4079 a_13714_n17054.n5 a_13714_n17054.n4 17.7215
R4080 a_13714_n17054.n4 a_13714_n17054.t6 21.2717
R4081 a_13714_n17054.n4 a_13714_n17054.t7 21.0558
R4082 a_13714_n17054.n5 a_13714_n17054.n3 29.0118
R4083 a_13714_n17054.n3 a_13714_n17054.t1 0.303833
R4084 a_13714_n17054.n3 a_13714_n17054.t0 0.303833
R4085 a_13714_n17054.n2 a_13714_n17054.n1 9.0005
R4086 a_13714_n17054.n1 a_13714_n17054.t4 20.9387
R4087 a_13714_n17054.n1 a_13714_n17054.t2 21.3888
R4088 a_9934_n17054.t0 a_9934_n17054.n0 6.7565
R4089 a_9934_n17054.n0 a_9934_n17054.n3 9.5495
R4090 a_9934_n17054.n3 a_9934_n17054.n2 13.9145
R4091 a_9934_n17054.n2 a_9934_n17054.t2 6.7565
R4092 a_9934_n17054.n2 a_9934_n17054.t1 6.302
R4093 a_9934_n17054.n3 a_9934_n17054.n1 19.6714
R4094 a_9934_n17054.n1 a_9934_n17054.t5 0.228
R4095 a_9934_n17054.n1 a_9934_n17054.t4 0.228
R4096 a_9934_n17054.n0 a_9934_n17054.t3 6.302
R4097 a_15128_n19574.t1 a_15128_n19574.n1 15.7616
R4098 a_15128_n19574.n1 a_15128_n19574.n0 0.4955
R4099 a_15128_n19574.n1 a_15128_n19574.t3 58.287
R4100 a_15128_n19574.n0 a_15128_n19574.t2 24.2221
R4101 a_15128_n19574.n0 a_15128_n19574.t0 54.9754
R4102 a_2982_n17114.t0 a_2982_n17114.n0 14.9362
R4103 a_2982_n17114.n0 a_2982_n17114.n3 4.5005
R4104 a_2982_n17114.n3 a_2982_n17114.n2 18.338
R4105 a_2982_n17114.n2 a_2982_n17114.t3 40.9507
R4106 a_2982_n17114.n2 a_2982_n17114.t4 40.9463
R4107 a_2982_n17114.n3 a_2982_n17114.n1 8.789
R4108 a_2982_n17114.n1 a_2982_n17114.t2 10.5574
R4109 a_2982_n17114.n1 a_2982_n17114.t1 50.1712
R4110 a_2982_n17114.n0 a_2982_n17114.t5 50.6618
R4111 a_34356_n15814.t0 a_34356_n15814.t1 23.3323
R4112 a_31212_n15294.t0 a_31212_n15294.t1 23.3323
R4113 a_34356_n14774.t0 a_34356_n14774.t1 23.3323
R4114 a_31212_n14254.t0 a_31212_n14254.t1 23.3323
R4115 a_34356_n13734.t0 a_34356_n13734.t1 23.3323
R4116 a_3336_n12918.t1 a_3336_n12918.n0 37.8095
R4117 a_3336_n12918.n0 a_3336_n12918.n1 3.0605
R4118 a_3336_n12918.n1 a_3336_n12918.n3 11.4867
R4119 a_3336_n12918.n3 a_3336_n12918.t4 4.76474
R4120 a_3336_n12918.n3 a_3336_n12918.n2 23.5353
R4121 a_3336_n12918.n2 a_3336_n12918.t2 0.303833
R4122 a_3336_n12918.n2 a_3336_n12918.t3 0.303833
R4123 a_3336_n12918.n1 a_3336_n12918.t5 61.5687
R4124 a_3336_n12918.n0 a_3336_n12918.t0 22.9358
R4125 a_31212_n13214.t0 a_31212_n13214.t1 23.3323
R4126 a_25264_n12918.t0 a_25264_n12918.t1 23.3323
R4127 a_19136_n12918.t0 a_19136_n12918.t1 23.3323
R4128 a_13712_n12918.t0 a_13712_n12918.t1 23.3323
R4129 a_7700_n12918.t0 a_7700_n12918.t1 23.3323
R4130 a_34356_n12694.t0 a_34356_n12694.t1 23.3323
R4131 a_21936_n12398.t0 a_21936_n12398.t1 23.3323
R4132 a_15736_n12398.t0 a_15736_n12398.t1 23.3323
R4133 a_9736_n12398.t0 a_9736_n12398.t1 23.3323
R4134 a_3336_n12398.t0 a_3336_n12398.t1 23.3323
R4135 a_31212_n12174.t0 a_31212_n12174.t1 23.3323
R4136 a_17294_n17114.t0 a_17294_n17114.n0 33.008
R4137 a_17294_n17114.n0 a_17294_n17114.n1 19.508
R4138 a_17294_n17114.n1 a_17294_n17114.t2 21.2147
R4139 a_17294_n17114.n1 a_17294_n17114.t3 21.2102
R4140 a_17294_n17114.n0 a_17294_n17114.t1 28.688
R4141 a_13712_n11878.t0 a_13712_n11878.t1 23.3323
R4142 a_7700_n11878.t0 a_7700_n11878.t1 23.3323
R4143 a_34356_n11654.t0 a_34356_n11654.t1 23.3323
R4144 a_25264_n11438.t0 a_25264_n11438.t1 23.3323
R4145 a_18870_n11438.t0 a_18870_n11438.t1 23.3323
R4146 a_2920_n19634.t2 a_2920_n19634.n3 32.1665
R4147 a_2920_n19634.n1 a_2920_n19634.n0 2.95925
R4148 a_2920_n19634.n2 a_2920_n19634.n1 3.3755
R4149 a_2920_n19634.n3 a_2920_n19634.n2 3.3755
R4150 a_2920_n19634.n3 a_2920_n19634.t3 54.7215
R4151 a_2920_n19634.n2 a_2920_n19634.t4 41.0197
R4152 a_2920_n19634.n1 a_2920_n19634.t5 41.0215
R4153 a_2920_n19634.n0 a_2920_n19634.t1 20.6632
R4154 a_2920_n19634.n0 a_2920_n19634.t0 44.865
R4155 a_9736_n11358.t0 a_9736_n11358.t1 23.3323
R4156 a_3336_n11358.t0 a_3336_n11358.t1 23.3323
R4157 a_31212_n11134.t0 a_31212_n11134.t1 23.3323
R4158 a_21936_n10918.t0 a_21936_n10918.t1 23.3323
R4159 a_15736_n10918.t0 a_15736_n10918.t1 23.3323
R4160 a_10742_n10398.t1 a_10742_n10398.t0 56.264
R4161 a_9736_n10398.t1 a_9736_n10398.n0 40.208
R4162 a_9736_n10398.n0 a_9736_n10398.n1 7.45925
R4163 a_9736_n10398.n1 a_9736_n10398.n2 18.6418
R4164 a_9736_n10398.n2 a_9736_n10398.t3 33.7767
R4165 a_9736_n10398.n2 a_9736_n10398.t4 33.5202
R4166 a_9736_n10398.n1 a_9736_n10398.t0 16.7516
R4167 a_9736_n10398.n0 a_9736_n10398.t2 19.5961
R4168 a_7700_n10838.t0 a_7700_n10838.t1 23.3323
R4169 a_34356_n10614.t0 a_34356_n10614.t1 23.3323
R4170 a_10256_n9958.t3 a_10256_n9958.n1 36.5945
R4171 a_10256_n9958.n0 a_10256_n9958.t0 4.5005
R4172 a_10256_n9958.n1 a_10256_n9958.t2 9.59675
R4173 a_10256_n9958.n1 a_10256_n9958.n0 2.03675
R4174 a_10256_n9958.n0 a_10256_n9958.t1 11.633
R4175 a_9736_n9958.t4 a_9736_n9958.n1 40.0843
R4176 a_9736_n9958.n1 a_9736_n9958.n4 3.47675
R4177 a_9736_n9958.n4 a_9736_n9958.n5 27.3568
R4178 a_9736_n9958.n5 a_9736_n9958.t2 0.2735
R4179 a_9736_n9958.n5 a_9736_n9958.t3 0.2735
R4180 a_9736_n9958.n4 a_9736_n9958.n2 17.3142
R4181 a_9736_n9958.n2 a_9736_n9958.n3 0.2525
R4182 a_9736_n9958.n3 a_9736_n9958.t5 62.7592
R4183 a_9736_n9958.n3 a_9736_n9958.t6 62.5072
R4184 a_9736_n9958.n2 a_9736_n9958.t7 62.5072
R4185 a_9736_n9958.n1 a_9736_n9958.n0 16.3938
R4186 a_9736_n9958.n0 a_9736_n9958.t0 0.303833
R4187 a_9736_n9958.n0 a_9736_n9958.t1 0.303833
R4188 a_3336_n10318.t0 a_3336_n10318.t1 23.3323
R4189 a_31212_n10094.t0 a_31212_n10094.t1 23.3323
R4190 a_7700_n9798.t0 a_7700_n9798.t1 23.3323
R4191 a_34356_n9574.t0 a_34356_n9574.t1 23.3323
R4192 a_3336_n9278.t0 a_3336_n9278.t1 23.3323
R4193 a_31212_n9054.t0 a_31212_n9054.t1 23.3323
R4194 a_7700_n8758.t0 a_7700_n8758.t1 23.3323
R4195 a_3336_n8238.t0 a_3336_n8238.n2 28.3505
R4196 a_3336_n8238.n2 a_3336_n8238.n1 1.823
R4197 a_3336_n8238.n2 a_3336_n8238.t2 32.4095
R4198 a_3336_n8238.n1 a_3336_n8238.n0 15.413
R4199 a_3336_n8238.n0 a_3336_n8238.t3 21.2147
R4200 a_3336_n8238.n0 a_3336_n8238.t4 21.2102
R4201 a_3336_n8238.n1 a_3336_n8238.t1 44.078
R4202 a_34356_n8534.t0 a_34356_n8534.t1 23.3323
R4203 a_31212_n8014.t0 a_31212_n8014.t1 23.3323
R4204 a_34356_n7494.t0 a_34356_n7494.t1 23.3323
R4205 a_31212_n6974.t0 a_31212_n6974.t1 23.3323
R4206 a_34356_n6454.t0 a_34356_n6454.t1 23.3323
R4207 a_31212_n5934.t0 a_31212_n5934.t1 23.3323
R4208 a_34356_n5414.t0 a_34356_n5414.t1 23.3323
R4209 a_3032_n194.t3 a_3032_n194.n1 6.55061
R4210 a_3032_n194.n1 a_3032_n194.n51 30.1595
R4211 a_3032_n194.n50 a_3032_n194.n49 4.5005
R4212 a_3032_n194.n53 a_3032_n194.n54 4.5005
R4213 a_3032_n194.n58 a_3032_n194.n50 5.41898
R4214 a_3032_n194.n50 a_3032_n194.n53 6.3455
R4215 a_3032_n194.n51 a_3032_n194.n53 7.133
R4216 a_3032_n194.n56 a_3032_n194.n55 0.266516
R4217 a_3032_n194.n56 a_3032_n194.n57 0.237633
R4218 a_3032_n194.n61 a_3032_n194.n58 0.136529
R4219 a_3032_n194.n58 a_3032_n194.n57 0.816881
R4220 a_3032_n194.n57 a_3032_n194.n54 0.283447
R4221 a_3032_n194.n54 a_3032_n194.n55 0.257666
R4222 a_3032_n194.n55 a_3032_n194.n52 0.816753
R4223 a_3032_n194.n51 a_3032_n194.n52 4.64289
R4224 a_3032_n194.n61 a_3032_n194.t6 0.0646724
R4225 a_3032_n194.n60 a_3032_n194.n61 0.0223182
R4226 a_3032_n194.n60 a_3032_n194.t5 0.0646724
R4227 a_3032_n194.n60 a_3032_n194.n56 0.00266028
R4228 a_3032_n194.n59 a_3032_n194.n60 0.0223182
R4229 a_3032_n194.n59 a_3032_n194.t4 0.0646724
R4230 a_3032_n194.n52 a_3032_n194.n59 0.122079
R4231 a_3032_n194.n49 a_3032_n194.t0 26.4626
R4232 a_3032_n194.n49 a_3032_n194.n48 10.598
R4233 a_3032_n194.n3 a_3032_n194.n2 0.1805
R4234 a_3032_n194.n4 a_3032_n194.n3 0.1805
R4235 a_3032_n194.n5 a_3032_n194.n4 0.1805
R4236 a_3032_n194.n6 a_3032_n194.n5 0.1805
R4237 a_3032_n194.n7 a_3032_n194.n6 0.1805
R4238 a_3032_n194.n8 a_3032_n194.n7 0.1805
R4239 a_3032_n194.n9 a_3032_n194.n8 0.1805
R4240 a_3032_n194.n10 a_3032_n194.n9 0.1805
R4241 a_3032_n194.n11 a_3032_n194.n10 0.1805
R4242 a_3032_n194.n12 a_3032_n194.n11 0.1805
R4243 a_3032_n194.n13 a_3032_n194.n12 0.1805
R4244 a_3032_n194.n14 a_3032_n194.n13 0.1805
R4245 a_3032_n194.n15 a_3032_n194.n14 0.1805
R4246 a_3032_n194.n16 a_3032_n194.n15 0.1805
R4247 a_3032_n194.n17 a_3032_n194.n16 0.1805
R4248 a_3032_n194.n18 a_3032_n194.n17 0.1805
R4249 a_3032_n194.n19 a_3032_n194.n18 0.1805
R4250 a_3032_n194.n20 a_3032_n194.n19 0.1805
R4251 a_3032_n194.n21 a_3032_n194.n20 0.1805
R4252 a_3032_n194.n22 a_3032_n194.n21 0.1805
R4253 a_3032_n194.n23 a_3032_n194.n22 0.1805
R4254 a_3032_n194.n24 a_3032_n194.n23 0.1805
R4255 a_3032_n194.n48 a_3032_n194.n24 0.095
R4256 a_3032_n194.n48 a_3032_n194.n25 0.086
R4257 a_3032_n194.n25 a_3032_n194.n26 0.1805
R4258 a_3032_n194.n26 a_3032_n194.n27 0.1805
R4259 a_3032_n194.n27 a_3032_n194.n28 0.1805
R4260 a_3032_n194.n28 a_3032_n194.n29 0.1805
R4261 a_3032_n194.n29 a_3032_n194.n30 0.1805
R4262 a_3032_n194.n30 a_3032_n194.n31 0.1805
R4263 a_3032_n194.n31 a_3032_n194.n32 0.1805
R4264 a_3032_n194.n32 a_3032_n194.n33 0.1805
R4265 a_3032_n194.n33 a_3032_n194.n34 0.1805
R4266 a_3032_n194.n34 a_3032_n194.n35 0.1805
R4267 a_3032_n194.n35 a_3032_n194.n36 0.1805
R4268 a_3032_n194.n36 a_3032_n194.n37 0.1805
R4269 a_3032_n194.n37 a_3032_n194.n38 0.1805
R4270 a_3032_n194.n38 a_3032_n194.n39 0.1805
R4271 a_3032_n194.n39 a_3032_n194.n40 0.1805
R4272 a_3032_n194.n40 a_3032_n194.n41 0.1805
R4273 a_3032_n194.n41 a_3032_n194.n42 0.1805
R4274 a_3032_n194.n42 a_3032_n194.n43 0.1805
R4275 a_3032_n194.n43 a_3032_n194.n44 0.1805
R4276 a_3032_n194.n44 a_3032_n194.n45 0.1805
R4277 a_3032_n194.n45 a_3032_n194.n46 0.1805
R4278 a_3032_n194.n46 a_3032_n194.n47 0.1805
R4279 a_3032_n194.n47 a_3032_n194.t7 71.7948
R4280 a_3032_n194.n47 a_3032_n194.t8 71.6148
R4281 a_3032_n194.n46 a_3032_n194.t9 71.6148
R4282 a_3032_n194.n45 a_3032_n194.t10 71.6148
R4283 a_3032_n194.n44 a_3032_n194.t11 71.6148
R4284 a_3032_n194.n43 a_3032_n194.t12 71.6148
R4285 a_3032_n194.n42 a_3032_n194.t13 71.6148
R4286 a_3032_n194.n41 a_3032_n194.t14 71.6148
R4287 a_3032_n194.n40 a_3032_n194.t15 71.6148
R4288 a_3032_n194.n39 a_3032_n194.t16 71.6148
R4289 a_3032_n194.n38 a_3032_n194.t17 71.6148
R4290 a_3032_n194.n37 a_3032_n194.t18 71.6148
R4291 a_3032_n194.n36 a_3032_n194.t19 71.6148
R4292 a_3032_n194.n35 a_3032_n194.t20 71.6148
R4293 a_3032_n194.n34 a_3032_n194.t21 71.6148
R4294 a_3032_n194.n33 a_3032_n194.t22 71.6148
R4295 a_3032_n194.n32 a_3032_n194.t23 71.6148
R4296 a_3032_n194.n31 a_3032_n194.t24 71.6148
R4297 a_3032_n194.n30 a_3032_n194.t25 71.6148
R4298 a_3032_n194.n29 a_3032_n194.t26 71.6148
R4299 a_3032_n194.n28 a_3032_n194.t27 71.6148
R4300 a_3032_n194.n27 a_3032_n194.t28 71.6148
R4301 a_3032_n194.n26 a_3032_n194.t29 71.6148
R4302 a_3032_n194.n25 a_3032_n194.t30 71.6148
R4303 a_3032_n194.n24 a_3032_n194.t31 71.6148
R4304 a_3032_n194.n23 a_3032_n194.t32 71.6148
R4305 a_3032_n194.n22 a_3032_n194.t33 71.6148
R4306 a_3032_n194.n21 a_3032_n194.t34 71.6148
R4307 a_3032_n194.n20 a_3032_n194.t35 71.6148
R4308 a_3032_n194.n19 a_3032_n194.t36 71.6148
R4309 a_3032_n194.n18 a_3032_n194.t37 71.6148
R4310 a_3032_n194.n17 a_3032_n194.t38 71.6148
R4311 a_3032_n194.n16 a_3032_n194.t39 71.6148
R4312 a_3032_n194.n15 a_3032_n194.t40 71.6148
R4313 a_3032_n194.n14 a_3032_n194.t41 71.6148
R4314 a_3032_n194.n13 a_3032_n194.t42 71.6148
R4315 a_3032_n194.n12 a_3032_n194.t43 71.6148
R4316 a_3032_n194.n11 a_3032_n194.t44 71.6148
R4317 a_3032_n194.n10 a_3032_n194.t45 71.6148
R4318 a_3032_n194.n9 a_3032_n194.t46 71.6148
R4319 a_3032_n194.n8 a_3032_n194.t47 71.6148
R4320 a_3032_n194.n7 a_3032_n194.t48 71.6148
R4321 a_3032_n194.n6 a_3032_n194.t49 71.6148
R4322 a_3032_n194.n5 a_3032_n194.t50 71.6148
R4323 a_3032_n194.n4 a_3032_n194.t51 71.6148
R4324 a_3032_n194.n3 a_3032_n194.t52 71.6148
R4325 a_3032_n194.n2 a_3032_n194.t53 71.6148
R4326 a_3032_n194.n2 a_3032_n194.t54 71.7948
R4327 a_3032_n194.n1 a_3032_n194.n0 5.72261
R4328 a_3032_n194.n0 a_3032_n194.t1 0.20525
R4329 a_3032_n194.n0 a_3032_n194.t2 0.20525
R4330 a_20408_5436.t1 a_20408_5436.t0 5.93781
R4331 a_19798_5436.t1 a_19798_5436.t0 5.93781
R4332 a_19148_5436.t1 a_19148_5436.t0 5.93781
R4333 a_17394_5754.t0 a_17394_5754.n0 2.9255
R4334 a_17394_5754.n0 a_17394_5754.t2 2.9255
R4335 a_17394_5754.n0 a_17394_5754.t1 17.6366
R4336 a_15568_5748.n0 a_15568_5748.t2 2.9255
R4337 a_15568_5748.t0 a_15568_5748.n0 2.9255
R4338 a_15568_5748.n0 a_15568_5748.t1 17.6366
R4339 a_18976_6174.t2 a_18976_6174.n0 5.92419
R4340 a_18976_6174.n0 a_18976_6174.n1 0.838192
R4341 a_18976_6174.n1 a_18976_6174.t3 20.1285
R4342 a_18976_6174.n1 a_18976_6174.t0 20.087
R4343 a_18976_6174.n0 a_18976_6174.t1 2.738
R4344 a_16312_6176.t1 a_16312_6176.n0 10.9942
R4345 a_16312_6176.n0 a_16312_6176.t0 5.47754
R4346 a_16312_6176.n0 a_16312_6176.t2 37.4935
R4347 a_16794_6306.t1 a_16794_6306.n1 10.8513
R4348 a_16794_6306.n1 a_16794_6306.n2 0.379055
R4349 a_16794_6306.n2 a_16794_6306.t2 11.3072
R4350 a_16794_6306.n2 a_16794_6306.t0 5.45015
R4351 a_16794_6306.n1 a_16794_6306.n0 0.583633
R4352 a_16794_6306.n0 a_16794_6306.t4 34.4554
R4353 a_16794_6306.n0 a_16794_6306.t3 27.2297
R4354 a_20296_6374.t1 a_20296_6374.t0 3.43742
R4355 a_19036_6374.t1 a_19036_6374.t0 3.43742
R4356 a_22018_6314.t0 a_22018_6314.n0 26.3862
R4357 a_22018_6314.n0 a_22018_6314.n1 0.293
R4358 a_22018_6314.n1 a_22018_6314.n2 3.353
R4359 a_22018_6314.n2 a_22018_6314.t3 29.1212
R4360 a_22018_6314.n2 a_22018_6314.t4 20.5759
R4361 a_22018_6314.n1 a_22018_6314.t2 15.7398
R4362 a_22018_6314.n0 a_22018_6314.t1 25.4672
R4363 a_26120_7990.t0 a_26120_7990.t1 23.3323
R4364 a_22272_8510.t0 a_22272_8510.t1 23.3323
R4365 a_26120_9030.t0 a_26120_9030.t1 23.3323
R4366 a_22272_9550.t0 a_22272_9550.t1 23.3323
R4367 a_26120_10070.t0 a_26120_10070.t1 23.3323
R4368 a_22272_10590.t0 a_22272_10590.t1 23.3323
R4369 a_26120_11110.t0 a_26120_11110.t1 23.3323
R4370 a_22272_11630.t0 a_22272_11630.t1 23.3323
R4371 a_26120_12150.t0 a_26120_12150.t1 23.3323
R4372 a_31212_n4894.t0 a_31212_n4894.n773 36.833
R4373 a_31212_n4894.n0 a_31212_n4894.n631 9.0005
R4374 a_31212_n4894.n1 a_31212_n4894.n636 9.0005
R4375 a_31212_n4894.n1 a_31212_n4894.n639 11.179
R4376 a_31212_n4894.n0 a_31212_n4894.n1 2.17895
R4377 a_31212_n4894.n773 a_31212_n4894.n0 0.43565
R4378 a_31212_n4894.n773 a_31212_n4894.n2 0.5801
R4379 a_31212_n4894.n3 a_31212_n4894.n4 4.5005
R4380 a_31212_n4894.n5 a_31212_n4894.n6 4.5005
R4381 a_31212_n4894.n7 a_31212_n4894.n8 4.5005
R4382 a_31212_n4894.n9 a_31212_n4894.n10 4.5005
R4383 a_31212_n4894.n11 a_31212_n4894.n12 4.5005
R4384 a_31212_n4894.n13 a_31212_n4894.n14 4.5005
R4385 a_31212_n4894.n15 a_31212_n4894.n16 4.5005
R4386 a_31212_n4894.n17 a_31212_n4894.n18 4.5005
R4387 a_31212_n4894.n19 a_31212_n4894.n20 4.5005
R4388 a_31212_n4894.n21 a_31212_n4894.n22 4.5005
R4389 a_31212_n4894.n23 a_31212_n4894.n24 4.5005
R4390 a_31212_n4894.n25 a_31212_n4894.n26 4.5005
R4391 a_31212_n4894.n27 a_31212_n4894.n28 4.5005
R4392 a_31212_n4894.n29 a_31212_n4894.n30 4.5005
R4393 a_31212_n4894.n31 a_31212_n4894.n32 4.5005
R4394 a_31212_n4894.n33 a_31212_n4894.n34 4.5005
R4395 a_31212_n4894.n35 a_31212_n4894.n36 4.5005
R4396 a_31212_n4894.n37 a_31212_n4894.n38 4.5005
R4397 a_31212_n4894.n39 a_31212_n4894.n40 4.5005
R4398 a_31212_n4894.n41 a_31212_n4894.n42 4.5005
R4399 a_31212_n4894.n43 a_31212_n4894.n44 4.5005
R4400 a_31212_n4894.n45 a_31212_n4894.n46 4.5005
R4401 a_31212_n4894.n47 a_31212_n4894.n48 4.5005
R4402 a_31212_n4894.n49 a_31212_n4894.n50 4.5005
R4403 a_31212_n4894.n51 a_31212_n4894.n52 4.5005
R4404 a_31212_n4894.n53 a_31212_n4894.n54 4.5005
R4405 a_31212_n4894.n55 a_31212_n4894.n56 4.5005
R4406 a_31212_n4894.n57 a_31212_n4894.n58 4.5005
R4407 a_31212_n4894.n59 a_31212_n4894.n60 4.5005
R4408 a_31212_n4894.n61 a_31212_n4894.n62 4.5005
R4409 a_31212_n4894.n63 a_31212_n4894.n64 4.5005
R4410 a_31212_n4894.n65 a_31212_n4894.n66 4.5005
R4411 a_31212_n4894.n67 a_31212_n4894.n68 4.5005
R4412 a_31212_n4894.n69 a_31212_n4894.n70 4.5005
R4413 a_31212_n4894.n71 a_31212_n4894.n72 4.5005
R4414 a_31212_n4894.n73 a_31212_n4894.n74 4.5005
R4415 a_31212_n4894.n75 a_31212_n4894.n76 4.5005
R4416 a_31212_n4894.n77 a_31212_n4894.n78 4.5005
R4417 a_31212_n4894.n79 a_31212_n4894.n80 4.5005
R4418 a_31212_n4894.n81 a_31212_n4894.n82 4.5005
R4419 a_31212_n4894.n83 a_31212_n4894.n84 4.5005
R4420 a_31212_n4894.n85 a_31212_n4894.n86 4.5005
R4421 a_31212_n4894.n87 a_31212_n4894.n88 4.5005
R4422 a_31212_n4894.n89 a_31212_n4894.n90 4.5005
R4423 a_31212_n4894.n91 a_31212_n4894.n92 4.5005
R4424 a_31212_n4894.n93 a_31212_n4894.n94 4.5005
R4425 a_31212_n4894.n95 a_31212_n4894.n96 4.5005
R4426 a_31212_n4894.n97 a_31212_n4894.n98 4.5005
R4427 a_31212_n4894.n99 a_31212_n4894.n100 4.5005
R4428 a_31212_n4894.n101 a_31212_n4894.n102 4.5005
R4429 a_31212_n4894.n103 a_31212_n4894.n104 4.5005
R4430 a_31212_n4894.n105 a_31212_n4894.n106 4.5005
R4431 a_31212_n4894.n107 a_31212_n4894.n108 4.5005
R4432 a_31212_n4894.n109 a_31212_n4894.n110 4.5005
R4433 a_31212_n4894.n111 a_31212_n4894.n112 4.5005
R4434 a_31212_n4894.n113 a_31212_n4894.n114 4.5005
R4435 a_31212_n4894.n115 a_31212_n4894.n116 4.5005
R4436 a_31212_n4894.n117 a_31212_n4894.n118 4.5005
R4437 a_31212_n4894.n119 a_31212_n4894.n120 4.5005
R4438 a_31212_n4894.n121 a_31212_n4894.n122 4.5005
R4439 a_31212_n4894.n123 a_31212_n4894.n124 4.5005
R4440 a_31212_n4894.n125 a_31212_n4894.n126 4.5005
R4441 a_31212_n4894.n127 a_31212_n4894.n128 4.5005
R4442 a_31212_n4894.n129 a_31212_n4894.n130 4.5005
R4443 a_31212_n4894.n131 a_31212_n4894.n132 4.5005
R4444 a_31212_n4894.n133 a_31212_n4894.n134 4.5005
R4445 a_31212_n4894.n135 a_31212_n4894.n136 4.5005
R4446 a_31212_n4894.n137 a_31212_n4894.n138 4.5005
R4447 a_31212_n4894.n139 a_31212_n4894.n140 4.5005
R4448 a_31212_n4894.n141 a_31212_n4894.n142 4.5005
R4449 a_31212_n4894.n143 a_31212_n4894.n144 4.5005
R4450 a_31212_n4894.n145 a_31212_n4894.n146 4.5005
R4451 a_31212_n4894.n147 a_31212_n4894.n148 4.5005
R4452 a_31212_n4894.n149 a_31212_n4894.n150 4.5005
R4453 a_31212_n4894.n151 a_31212_n4894.n152 4.5005
R4454 a_31212_n4894.n153 a_31212_n4894.n154 4.5005
R4455 a_31212_n4894.n155 a_31212_n4894.n156 4.5005
R4456 a_31212_n4894.n157 a_31212_n4894.n158 4.5005
R4457 a_31212_n4894.n159 a_31212_n4894.n160 4.5005
R4458 a_31212_n4894.n161 a_31212_n4894.n162 4.5005
R4459 a_31212_n4894.n163 a_31212_n4894.n164 4.5005
R4460 a_31212_n4894.n165 a_31212_n4894.n166 4.5005
R4461 a_31212_n4894.n167 a_31212_n4894.n168 4.5005
R4462 a_31212_n4894.n169 a_31212_n4894.n170 4.5005
R4463 a_31212_n4894.n171 a_31212_n4894.n172 4.5005
R4464 a_31212_n4894.n173 a_31212_n4894.n174 4.5005
R4465 a_31212_n4894.n175 a_31212_n4894.n176 4.5005
R4466 a_31212_n4894.n177 a_31212_n4894.n178 4.5005
R4467 a_31212_n4894.n179 a_31212_n4894.n180 4.5005
R4468 a_31212_n4894.n181 a_31212_n4894.n182 4.5005
R4469 a_31212_n4894.n183 a_31212_n4894.n184 4.5005
R4470 a_31212_n4894.n185 a_31212_n4894.n186 4.5005
R4471 a_31212_n4894.n187 a_31212_n4894.n188 4.5005
R4472 a_31212_n4894.n189 a_31212_n4894.n190 4.5005
R4473 a_31212_n4894.n191 a_31212_n4894.n192 4.5005
R4474 a_31212_n4894.n193 a_31212_n4894.n194 4.5005
R4475 a_31212_n4894.n195 a_31212_n4894.n196 4.5005
R4476 a_31212_n4894.n197 a_31212_n4894.n198 4.5005
R4477 a_31212_n4894.n199 a_31212_n4894.n200 4.5005
R4478 a_31212_n4894.n201 a_31212_n4894.n202 4.5005
R4479 a_31212_n4894.n203 a_31212_n4894.n204 4.5005
R4480 a_31212_n4894.n205 a_31212_n4894.n206 4.5005
R4481 a_31212_n4894.n207 a_31212_n4894.n208 4.5005
R4482 a_31212_n4894.n209 a_31212_n4894.n210 4.5005
R4483 a_31212_n4894.n211 a_31212_n4894.n212 4.5005
R4484 a_31212_n4894.n213 a_31212_n4894.n214 4.5005
R4485 a_31212_n4894.n215 a_31212_n4894.n216 4.5005
R4486 a_31212_n4894.n217 a_31212_n4894.n218 4.5005
R4487 a_31212_n4894.n219 a_31212_n4894.n220 4.5005
R4488 a_31212_n4894.n221 a_31212_n4894.n222 4.5005
R4489 a_31212_n4894.n223 a_31212_n4894.n224 4.5005
R4490 a_31212_n4894.n225 a_31212_n4894.n226 4.5005
R4491 a_31212_n4894.n227 a_31212_n4894.n228 4.5005
R4492 a_31212_n4894.n229 a_31212_n4894.n230 4.5005
R4493 a_31212_n4894.n231 a_31212_n4894.n232 4.5005
R4494 a_31212_n4894.n233 a_31212_n4894.n234 4.5005
R4495 a_31212_n4894.n235 a_31212_n4894.n236 4.5005
R4496 a_31212_n4894.n237 a_31212_n4894.n238 4.5005
R4497 a_31212_n4894.n239 a_31212_n4894.n240 4.5005
R4498 a_31212_n4894.n241 a_31212_n4894.n242 4.5005
R4499 a_31212_n4894.n243 a_31212_n4894.n244 4.5005
R4500 a_31212_n4894.n245 a_31212_n4894.n246 4.5005
R4501 a_31212_n4894.n247 a_31212_n4894.n248 4.5005
R4502 a_31212_n4894.n249 a_31212_n4894.n250 4.5005
R4503 a_31212_n4894.n251 a_31212_n4894.n252 4.5005
R4504 a_31212_n4894.n253 a_31212_n4894.n254 4.5005
R4505 a_31212_n4894.n255 a_31212_n4894.n256 4.5005
R4506 a_31212_n4894.n257 a_31212_n4894.n258 4.5005
R4507 a_31212_n4894.n259 a_31212_n4894.n260 4.5005
R4508 a_31212_n4894.n261 a_31212_n4894.n262 4.5005
R4509 a_31212_n4894.n263 a_31212_n4894.n264 4.5005
R4510 a_31212_n4894.n265 a_31212_n4894.n266 4.5005
R4511 a_31212_n4894.n267 a_31212_n4894.n268 4.5005
R4512 a_31212_n4894.n269 a_31212_n4894.n270 4.5005
R4513 a_31212_n4894.n271 a_31212_n4894.n272 4.5005
R4514 a_31212_n4894.n273 a_31212_n4894.n274 4.5005
R4515 a_31212_n4894.n275 a_31212_n4894.n276 4.5005
R4516 a_31212_n4894.n277 a_31212_n4894.n278 4.5005
R4517 a_31212_n4894.n279 a_31212_n4894.n280 4.5005
R4518 a_31212_n4894.n281 a_31212_n4894.n282 4.5005
R4519 a_31212_n4894.n283 a_31212_n4894.n284 4.5005
R4520 a_31212_n4894.n285 a_31212_n4894.n286 4.5005
R4521 a_31212_n4894.n287 a_31212_n4894.n288 4.5005
R4522 a_31212_n4894.n289 a_31212_n4894.n290 4.5005
R4523 a_31212_n4894.n291 a_31212_n4894.n292 4.5005
R4524 a_31212_n4894.n293 a_31212_n4894.n294 4.5005
R4525 a_31212_n4894.n295 a_31212_n4894.n296 4.5005
R4526 a_31212_n4894.n297 a_31212_n4894.n298 4.5005
R4527 a_31212_n4894.n299 a_31212_n4894.n300 4.5005
R4528 a_31212_n4894.n301 a_31212_n4894.n302 4.5005
R4529 a_31212_n4894.n303 a_31212_n4894.n304 4.5005
R4530 a_31212_n4894.n305 a_31212_n4894.n306 4.5005
R4531 a_31212_n4894.n307 a_31212_n4894.n308 4.5005
R4532 a_31212_n4894.n309 a_31212_n4894.n310 4.5005
R4533 a_31212_n4894.n311 a_31212_n4894.n312 4.5005
R4534 a_31212_n4894.n313 a_31212_n4894.n314 4.5005
R4535 a_31212_n4894.n315 a_31212_n4894.n316 4.5005
R4536 a_31212_n4894.n317 a_31212_n4894.n318 4.5005
R4537 a_31212_n4894.n319 a_31212_n4894.n320 4.5005
R4538 a_31212_n4894.n321 a_31212_n4894.n322 4.5005
R4539 a_31212_n4894.n323 a_31212_n4894.n324 4.5005
R4540 a_31212_n4894.n325 a_31212_n4894.n326 4.5005
R4541 a_31212_n4894.n327 a_31212_n4894.n328 4.5005
R4542 a_31212_n4894.n329 a_31212_n4894.n330 4.5005
R4543 a_31212_n4894.n331 a_31212_n4894.n332 4.5005
R4544 a_31212_n4894.n333 a_31212_n4894.n334 4.5005
R4545 a_31212_n4894.n335 a_31212_n4894.n336 4.5005
R4546 a_31212_n4894.n337 a_31212_n4894.n338 4.5005
R4547 a_31212_n4894.n339 a_31212_n4894.n340 4.5005
R4548 a_31212_n4894.n341 a_31212_n4894.n342 4.5005
R4549 a_31212_n4894.n343 a_31212_n4894.n344 4.5005
R4550 a_31212_n4894.n345 a_31212_n4894.n346 4.5005
R4551 a_31212_n4894.n347 a_31212_n4894.n348 4.5005
R4552 a_31212_n4894.n349 a_31212_n4894.n350 4.5005
R4553 a_31212_n4894.n351 a_31212_n4894.n352 4.5005
R4554 a_31212_n4894.n353 a_31212_n4894.n354 4.5005
R4555 a_31212_n4894.n355 a_31212_n4894.n356 4.5005
R4556 a_31212_n4894.n357 a_31212_n4894.n358 4.5005
R4557 a_31212_n4894.n359 a_31212_n4894.n360 4.5005
R4558 a_31212_n4894.n361 a_31212_n4894.n362 4.5005
R4559 a_31212_n4894.n3 a_31212_n4894.n363 4.5005
R4560 a_31212_n4894.n5 a_31212_n4894.n364 4.5005
R4561 a_31212_n4894.n7 a_31212_n4894.n365 4.5005
R4562 a_31212_n4894.n9 a_31212_n4894.n366 4.5005
R4563 a_31212_n4894.n11 a_31212_n4894.n367 4.5005
R4564 a_31212_n4894.n13 a_31212_n4894.n368 4.5005
R4565 a_31212_n4894.n15 a_31212_n4894.n369 4.5005
R4566 a_31212_n4894.n17 a_31212_n4894.n370 4.5005
R4567 a_31212_n4894.n19 a_31212_n4894.n371 4.5005
R4568 a_31212_n4894.n21 a_31212_n4894.n372 4.5005
R4569 a_31212_n4894.n23 a_31212_n4894.n373 4.5005
R4570 a_31212_n4894.n25 a_31212_n4894.n374 4.5005
R4571 a_31212_n4894.n27 a_31212_n4894.n375 4.5005
R4572 a_31212_n4894.n29 a_31212_n4894.n376 4.5005
R4573 a_31212_n4894.n31 a_31212_n4894.n377 4.5005
R4574 a_31212_n4894.n33 a_31212_n4894.n378 4.5005
R4575 a_31212_n4894.n35 a_31212_n4894.n379 4.5005
R4576 a_31212_n4894.n37 a_31212_n4894.n380 4.5005
R4577 a_31212_n4894.n39 a_31212_n4894.n381 4.5005
R4578 a_31212_n4894.n41 a_31212_n4894.n382 4.5005
R4579 a_31212_n4894.n43 a_31212_n4894.n383 4.5005
R4580 a_31212_n4894.n45 a_31212_n4894.n384 4.5005
R4581 a_31212_n4894.n47 a_31212_n4894.n385 4.5005
R4582 a_31212_n4894.n49 a_31212_n4894.n386 4.5005
R4583 a_31212_n4894.n51 a_31212_n4894.n387 4.5005
R4584 a_31212_n4894.n53 a_31212_n4894.n388 4.5005
R4585 a_31212_n4894.n55 a_31212_n4894.n389 4.5005
R4586 a_31212_n4894.n57 a_31212_n4894.n390 4.5005
R4587 a_31212_n4894.n59 a_31212_n4894.n391 4.5005
R4588 a_31212_n4894.n61 a_31212_n4894.n392 4.5005
R4589 a_31212_n4894.n63 a_31212_n4894.n393 4.5005
R4590 a_31212_n4894.n65 a_31212_n4894.n394 4.5005
R4591 a_31212_n4894.n67 a_31212_n4894.n395 4.5005
R4592 a_31212_n4894.n69 a_31212_n4894.n396 4.5005
R4593 a_31212_n4894.n71 a_31212_n4894.n397 4.5005
R4594 a_31212_n4894.n73 a_31212_n4894.n398 4.5005
R4595 a_31212_n4894.n75 a_31212_n4894.n399 4.5005
R4596 a_31212_n4894.n77 a_31212_n4894.n400 4.5005
R4597 a_31212_n4894.n79 a_31212_n4894.n401 4.5005
R4598 a_31212_n4894.n81 a_31212_n4894.n402 4.5005
R4599 a_31212_n4894.n83 a_31212_n4894.n403 4.5005
R4600 a_31212_n4894.n85 a_31212_n4894.n404 4.5005
R4601 a_31212_n4894.n87 a_31212_n4894.n405 4.5005
R4602 a_31212_n4894.n89 a_31212_n4894.n406 4.5005
R4603 a_31212_n4894.n91 a_31212_n4894.n407 4.5005
R4604 a_31212_n4894.n93 a_31212_n4894.n408 4.5005
R4605 a_31212_n4894.n95 a_31212_n4894.n409 4.5005
R4606 a_31212_n4894.n97 a_31212_n4894.n410 4.5005
R4607 a_31212_n4894.n99 a_31212_n4894.n411 4.5005
R4608 a_31212_n4894.n101 a_31212_n4894.n412 4.5005
R4609 a_31212_n4894.n103 a_31212_n4894.n413 4.5005
R4610 a_31212_n4894.n105 a_31212_n4894.n414 4.5005
R4611 a_31212_n4894.n107 a_31212_n4894.n415 4.5005
R4612 a_31212_n4894.n109 a_31212_n4894.n416 4.5005
R4613 a_31212_n4894.n111 a_31212_n4894.n417 4.5005
R4614 a_31212_n4894.n113 a_31212_n4894.n418 4.5005
R4615 a_31212_n4894.n115 a_31212_n4894.n419 4.5005
R4616 a_31212_n4894.n117 a_31212_n4894.n420 4.5005
R4617 a_31212_n4894.n119 a_31212_n4894.n421 4.5005
R4618 a_31212_n4894.n121 a_31212_n4894.n422 4.5005
R4619 a_31212_n4894.n123 a_31212_n4894.n423 4.5005
R4620 a_31212_n4894.n125 a_31212_n4894.n424 4.5005
R4621 a_31212_n4894.n127 a_31212_n4894.n425 4.5005
R4622 a_31212_n4894.n129 a_31212_n4894.n426 4.5005
R4623 a_31212_n4894.n131 a_31212_n4894.n427 4.5005
R4624 a_31212_n4894.n133 a_31212_n4894.n428 4.5005
R4625 a_31212_n4894.n135 a_31212_n4894.n429 4.5005
R4626 a_31212_n4894.n137 a_31212_n4894.n430 4.5005
R4627 a_31212_n4894.n139 a_31212_n4894.n431 4.5005
R4628 a_31212_n4894.n141 a_31212_n4894.n432 4.5005
R4629 a_31212_n4894.n143 a_31212_n4894.n433 4.5005
R4630 a_31212_n4894.n145 a_31212_n4894.n434 4.5005
R4631 a_31212_n4894.n147 a_31212_n4894.n435 4.5005
R4632 a_31212_n4894.n149 a_31212_n4894.n436 4.5005
R4633 a_31212_n4894.n151 a_31212_n4894.n437 4.5005
R4634 a_31212_n4894.n153 a_31212_n4894.n438 4.5005
R4635 a_31212_n4894.n155 a_31212_n4894.n439 4.5005
R4636 a_31212_n4894.n157 a_31212_n4894.n440 4.5005
R4637 a_31212_n4894.n159 a_31212_n4894.n441 4.5005
R4638 a_31212_n4894.n161 a_31212_n4894.n442 4.5005
R4639 a_31212_n4894.n163 a_31212_n4894.n443 4.5005
R4640 a_31212_n4894.n165 a_31212_n4894.n444 4.5005
R4641 a_31212_n4894.n167 a_31212_n4894.n445 4.5005
R4642 a_31212_n4894.n169 a_31212_n4894.n446 4.5005
R4643 a_31212_n4894.n171 a_31212_n4894.n447 4.5005
R4644 a_31212_n4894.n173 a_31212_n4894.n448 4.5005
R4645 a_31212_n4894.n175 a_31212_n4894.n449 4.5005
R4646 a_31212_n4894.n177 a_31212_n4894.n450 4.5005
R4647 a_31212_n4894.n179 a_31212_n4894.n451 4.5005
R4648 a_31212_n4894.n181 a_31212_n4894.n452 4.5005
R4649 a_31212_n4894.n183 a_31212_n4894.n453 4.5005
R4650 a_31212_n4894.n185 a_31212_n4894.n454 4.5005
R4651 a_31212_n4894.n187 a_31212_n4894.n455 4.5005
R4652 a_31212_n4894.n189 a_31212_n4894.n456 4.5005
R4653 a_31212_n4894.n191 a_31212_n4894.n457 4.5005
R4654 a_31212_n4894.n193 a_31212_n4894.n458 4.5005
R4655 a_31212_n4894.n195 a_31212_n4894.n459 4.5005
R4656 a_31212_n4894.n197 a_31212_n4894.n460 4.5005
R4657 a_31212_n4894.n199 a_31212_n4894.n461 4.5005
R4658 a_31212_n4894.n201 a_31212_n4894.n462 4.5005
R4659 a_31212_n4894.n203 a_31212_n4894.n463 4.5005
R4660 a_31212_n4894.n205 a_31212_n4894.n464 4.5005
R4661 a_31212_n4894.n207 a_31212_n4894.n465 4.5005
R4662 a_31212_n4894.n209 a_31212_n4894.n466 4.5005
R4663 a_31212_n4894.n211 a_31212_n4894.n467 4.5005
R4664 a_31212_n4894.n213 a_31212_n4894.n468 4.5005
R4665 a_31212_n4894.n215 a_31212_n4894.n469 4.5005
R4666 a_31212_n4894.n217 a_31212_n4894.n470 4.5005
R4667 a_31212_n4894.n219 a_31212_n4894.n471 4.5005
R4668 a_31212_n4894.n221 a_31212_n4894.n472 4.5005
R4669 a_31212_n4894.n223 a_31212_n4894.n473 4.5005
R4670 a_31212_n4894.n225 a_31212_n4894.n474 4.5005
R4671 a_31212_n4894.n227 a_31212_n4894.n475 4.5005
R4672 a_31212_n4894.n229 a_31212_n4894.n476 4.5005
R4673 a_31212_n4894.n231 a_31212_n4894.n477 4.5005
R4674 a_31212_n4894.n233 a_31212_n4894.n478 4.5005
R4675 a_31212_n4894.n235 a_31212_n4894.n479 4.5005
R4676 a_31212_n4894.n237 a_31212_n4894.n480 4.5005
R4677 a_31212_n4894.n239 a_31212_n4894.n481 4.5005
R4678 a_31212_n4894.n241 a_31212_n4894.n482 4.5005
R4679 a_31212_n4894.n243 a_31212_n4894.n483 4.5005
R4680 a_31212_n4894.n245 a_31212_n4894.n484 4.5005
R4681 a_31212_n4894.n247 a_31212_n4894.n485 4.5005
R4682 a_31212_n4894.n249 a_31212_n4894.n486 4.5005
R4683 a_31212_n4894.n251 a_31212_n4894.n487 4.5005
R4684 a_31212_n4894.n253 a_31212_n4894.n488 4.5005
R4685 a_31212_n4894.n255 a_31212_n4894.n489 4.5005
R4686 a_31212_n4894.n257 a_31212_n4894.n490 4.5005
R4687 a_31212_n4894.n259 a_31212_n4894.n491 4.5005
R4688 a_31212_n4894.n261 a_31212_n4894.n492 4.5005
R4689 a_31212_n4894.n263 a_31212_n4894.n493 4.5005
R4690 a_31212_n4894.n265 a_31212_n4894.n494 4.5005
R4691 a_31212_n4894.n267 a_31212_n4894.n495 4.5005
R4692 a_31212_n4894.n269 a_31212_n4894.n496 4.5005
R4693 a_31212_n4894.n271 a_31212_n4894.n497 4.5005
R4694 a_31212_n4894.n273 a_31212_n4894.n498 4.5005
R4695 a_31212_n4894.n275 a_31212_n4894.n499 4.5005
R4696 a_31212_n4894.n277 a_31212_n4894.n500 4.5005
R4697 a_31212_n4894.n279 a_31212_n4894.n501 4.5005
R4698 a_31212_n4894.n281 a_31212_n4894.n502 4.5005
R4699 a_31212_n4894.n283 a_31212_n4894.n503 4.5005
R4700 a_31212_n4894.n285 a_31212_n4894.n504 4.5005
R4701 a_31212_n4894.n287 a_31212_n4894.n505 4.5005
R4702 a_31212_n4894.n289 a_31212_n4894.n506 4.5005
R4703 a_31212_n4894.n291 a_31212_n4894.n507 4.5005
R4704 a_31212_n4894.n293 a_31212_n4894.n508 4.5005
R4705 a_31212_n4894.n295 a_31212_n4894.n509 4.5005
R4706 a_31212_n4894.n297 a_31212_n4894.n510 4.5005
R4707 a_31212_n4894.n299 a_31212_n4894.n511 4.5005
R4708 a_31212_n4894.n301 a_31212_n4894.n512 4.5005
R4709 a_31212_n4894.n303 a_31212_n4894.n513 4.5005
R4710 a_31212_n4894.n305 a_31212_n4894.n514 4.5005
R4711 a_31212_n4894.n307 a_31212_n4894.n515 4.5005
R4712 a_31212_n4894.n309 a_31212_n4894.n516 4.5005
R4713 a_31212_n4894.n311 a_31212_n4894.n517 4.5005
R4714 a_31212_n4894.n313 a_31212_n4894.n518 4.5005
R4715 a_31212_n4894.n315 a_31212_n4894.n519 4.5005
R4716 a_31212_n4894.n317 a_31212_n4894.n520 4.5005
R4717 a_31212_n4894.n319 a_31212_n4894.n521 4.5005
R4718 a_31212_n4894.n321 a_31212_n4894.n522 4.5005
R4719 a_31212_n4894.n323 a_31212_n4894.n523 4.5005
R4720 a_31212_n4894.n325 a_31212_n4894.n524 4.5005
R4721 a_31212_n4894.n327 a_31212_n4894.n525 4.5005
R4722 a_31212_n4894.n329 a_31212_n4894.n526 4.5005
R4723 a_31212_n4894.n331 a_31212_n4894.n527 4.5005
R4724 a_31212_n4894.n333 a_31212_n4894.n528 4.5005
R4725 a_31212_n4894.n335 a_31212_n4894.n529 4.5005
R4726 a_31212_n4894.n337 a_31212_n4894.n530 4.5005
R4727 a_31212_n4894.n339 a_31212_n4894.n531 4.5005
R4728 a_31212_n4894.n341 a_31212_n4894.n532 4.5005
R4729 a_31212_n4894.n343 a_31212_n4894.n533 4.5005
R4730 a_31212_n4894.n345 a_31212_n4894.n534 4.5005
R4731 a_31212_n4894.n347 a_31212_n4894.n535 4.5005
R4732 a_31212_n4894.n349 a_31212_n4894.n536 4.5005
R4733 a_31212_n4894.n351 a_31212_n4894.n537 4.5005
R4734 a_31212_n4894.n353 a_31212_n4894.n538 4.5005
R4735 a_31212_n4894.n355 a_31212_n4894.n539 4.5005
R4736 a_31212_n4894.n357 a_31212_n4894.n540 4.5005
R4737 a_31212_n4894.n359 a_31212_n4894.n541 4.5005
R4738 a_31212_n4894.n361 a_31212_n4894.n542 4.5005
R4739 a_31212_n4894.n359 a_31212_n4894.n361 0.0258125
R4740 a_31212_n4894.n357 a_31212_n4894.n359 0.0258125
R4741 a_31212_n4894.n355 a_31212_n4894.n357 0.0258125
R4742 a_31212_n4894.n353 a_31212_n4894.n355 0.0258125
R4743 a_31212_n4894.n351 a_31212_n4894.n353 0.0258125
R4744 a_31212_n4894.n349 a_31212_n4894.n351 0.0258125
R4745 a_31212_n4894.n347 a_31212_n4894.n349 0.0258125
R4746 a_31212_n4894.n345 a_31212_n4894.n347 0.0258125
R4747 a_31212_n4894.n343 a_31212_n4894.n345 0.0258125
R4748 a_31212_n4894.n341 a_31212_n4894.n343 0.0258125
R4749 a_31212_n4894.n339 a_31212_n4894.n341 0.0258125
R4750 a_31212_n4894.n337 a_31212_n4894.n339 0.0258125
R4751 a_31212_n4894.n335 a_31212_n4894.n337 0.0258125
R4752 a_31212_n4894.n333 a_31212_n4894.n335 0.0258125
R4753 a_31212_n4894.n331 a_31212_n4894.n333 0.0258125
R4754 a_31212_n4894.n329 a_31212_n4894.n331 0.0258125
R4755 a_31212_n4894.n327 a_31212_n4894.n329 0.0258125
R4756 a_31212_n4894.n325 a_31212_n4894.n327 0.0258125
R4757 a_31212_n4894.n323 a_31212_n4894.n325 0.0258125
R4758 a_31212_n4894.n321 a_31212_n4894.n323 0.0258125
R4759 a_31212_n4894.n319 a_31212_n4894.n321 0.0258125
R4760 a_31212_n4894.n317 a_31212_n4894.n319 0.0258125
R4761 a_31212_n4894.n315 a_31212_n4894.n317 0.0258125
R4762 a_31212_n4894.n313 a_31212_n4894.n315 0.0258125
R4763 a_31212_n4894.n311 a_31212_n4894.n313 0.0258125
R4764 a_31212_n4894.n309 a_31212_n4894.n311 0.0258125
R4765 a_31212_n4894.n307 a_31212_n4894.n309 0.0258125
R4766 a_31212_n4894.n305 a_31212_n4894.n307 0.0258125
R4767 a_31212_n4894.n303 a_31212_n4894.n305 0.0258125
R4768 a_31212_n4894.n2 a_31212_n4894.n303 0.089375
R4769 a_31212_n4894.n2 a_31212_n4894.n301 0.0539375
R4770 a_31212_n4894.n301 a_31212_n4894.n299 0.0258125
R4771 a_31212_n4894.n299 a_31212_n4894.n297 0.0258125
R4772 a_31212_n4894.n297 a_31212_n4894.n295 0.0258125
R4773 a_31212_n4894.n295 a_31212_n4894.n293 0.0258125
R4774 a_31212_n4894.n293 a_31212_n4894.n291 0.0258125
R4775 a_31212_n4894.n291 a_31212_n4894.n289 0.0258125
R4776 a_31212_n4894.n289 a_31212_n4894.n287 0.0258125
R4777 a_31212_n4894.n287 a_31212_n4894.n285 0.0258125
R4778 a_31212_n4894.n285 a_31212_n4894.n283 0.0258125
R4779 a_31212_n4894.n283 a_31212_n4894.n281 0.0258125
R4780 a_31212_n4894.n281 a_31212_n4894.n279 0.0258125
R4781 a_31212_n4894.n279 a_31212_n4894.n277 0.0258125
R4782 a_31212_n4894.n277 a_31212_n4894.n275 0.0258125
R4783 a_31212_n4894.n275 a_31212_n4894.n273 0.0258125
R4784 a_31212_n4894.n273 a_31212_n4894.n271 0.0258125
R4785 a_31212_n4894.n271 a_31212_n4894.n269 0.0258125
R4786 a_31212_n4894.n269 a_31212_n4894.n267 0.0258125
R4787 a_31212_n4894.n267 a_31212_n4894.n265 0.0258125
R4788 a_31212_n4894.n265 a_31212_n4894.n263 0.0258125
R4789 a_31212_n4894.n263 a_31212_n4894.n261 0.0258125
R4790 a_31212_n4894.n261 a_31212_n4894.n259 0.0258125
R4791 a_31212_n4894.n259 a_31212_n4894.n257 0.0258125
R4792 a_31212_n4894.n257 a_31212_n4894.n255 0.0258125
R4793 a_31212_n4894.n255 a_31212_n4894.n253 0.0258125
R4794 a_31212_n4894.n253 a_31212_n4894.n251 0.0258125
R4795 a_31212_n4894.n251 a_31212_n4894.n249 0.0258125
R4796 a_31212_n4894.n249 a_31212_n4894.n247 0.0258125
R4797 a_31212_n4894.n247 a_31212_n4894.n245 0.0258125
R4798 a_31212_n4894.n245 a_31212_n4894.n243 0.0258125
R4799 a_31212_n4894.n243 a_31212_n4894.n772 0.089375
R4800 a_31212_n4894.n772 a_31212_n4894.n241 0.0539375
R4801 a_31212_n4894.n241 a_31212_n4894.n239 0.0258125
R4802 a_31212_n4894.n239 a_31212_n4894.n237 0.0258125
R4803 a_31212_n4894.n237 a_31212_n4894.n235 0.0258125
R4804 a_31212_n4894.n235 a_31212_n4894.n233 0.0258125
R4805 a_31212_n4894.n233 a_31212_n4894.n231 0.0258125
R4806 a_31212_n4894.n231 a_31212_n4894.n229 0.0258125
R4807 a_31212_n4894.n229 a_31212_n4894.n227 0.0258125
R4808 a_31212_n4894.n227 a_31212_n4894.n225 0.0258125
R4809 a_31212_n4894.n225 a_31212_n4894.n223 0.0258125
R4810 a_31212_n4894.n223 a_31212_n4894.n221 0.0258125
R4811 a_31212_n4894.n221 a_31212_n4894.n219 0.0258125
R4812 a_31212_n4894.n219 a_31212_n4894.n217 0.0258125
R4813 a_31212_n4894.n217 a_31212_n4894.n215 0.0258125
R4814 a_31212_n4894.n215 a_31212_n4894.n213 0.0258125
R4815 a_31212_n4894.n213 a_31212_n4894.n211 0.0258125
R4816 a_31212_n4894.n211 a_31212_n4894.n209 0.0258125
R4817 a_31212_n4894.n209 a_31212_n4894.n207 0.0258125
R4818 a_31212_n4894.n207 a_31212_n4894.n205 0.0258125
R4819 a_31212_n4894.n205 a_31212_n4894.n203 0.0258125
R4820 a_31212_n4894.n203 a_31212_n4894.n201 0.0258125
R4821 a_31212_n4894.n201 a_31212_n4894.n199 0.0258125
R4822 a_31212_n4894.n199 a_31212_n4894.n197 0.0258125
R4823 a_31212_n4894.n197 a_31212_n4894.n195 0.0258125
R4824 a_31212_n4894.n195 a_31212_n4894.n193 0.0258125
R4825 a_31212_n4894.n193 a_31212_n4894.n191 0.0258125
R4826 a_31212_n4894.n191 a_31212_n4894.n189 0.0258125
R4827 a_31212_n4894.n189 a_31212_n4894.n187 0.0258125
R4828 a_31212_n4894.n187 a_31212_n4894.n185 0.0258125
R4829 a_31212_n4894.n185 a_31212_n4894.n183 0.0258125
R4830 a_31212_n4894.n183 a_31212_n4894.n545 0.089375
R4831 a_31212_n4894.n545 a_31212_n4894.n181 0.0539375
R4832 a_31212_n4894.n181 a_31212_n4894.n179 0.0258125
R4833 a_31212_n4894.n179 a_31212_n4894.n177 0.0258125
R4834 a_31212_n4894.n177 a_31212_n4894.n175 0.0258125
R4835 a_31212_n4894.n175 a_31212_n4894.n173 0.0258125
R4836 a_31212_n4894.n173 a_31212_n4894.n171 0.0258125
R4837 a_31212_n4894.n171 a_31212_n4894.n169 0.0258125
R4838 a_31212_n4894.n169 a_31212_n4894.n167 0.0258125
R4839 a_31212_n4894.n167 a_31212_n4894.n165 0.0258125
R4840 a_31212_n4894.n165 a_31212_n4894.n163 0.0258125
R4841 a_31212_n4894.n163 a_31212_n4894.n161 0.0258125
R4842 a_31212_n4894.n161 a_31212_n4894.n159 0.0258125
R4843 a_31212_n4894.n159 a_31212_n4894.n157 0.0258125
R4844 a_31212_n4894.n157 a_31212_n4894.n155 0.0258125
R4845 a_31212_n4894.n155 a_31212_n4894.n153 0.0258125
R4846 a_31212_n4894.n153 a_31212_n4894.n151 0.0258125
R4847 a_31212_n4894.n151 a_31212_n4894.n149 0.0258125
R4848 a_31212_n4894.n149 a_31212_n4894.n147 0.0258125
R4849 a_31212_n4894.n147 a_31212_n4894.n145 0.0258125
R4850 a_31212_n4894.n145 a_31212_n4894.n143 0.0258125
R4851 a_31212_n4894.n143 a_31212_n4894.n141 0.0258125
R4852 a_31212_n4894.n141 a_31212_n4894.n139 0.0258125
R4853 a_31212_n4894.n139 a_31212_n4894.n137 0.0258125
R4854 a_31212_n4894.n137 a_31212_n4894.n135 0.0258125
R4855 a_31212_n4894.n135 a_31212_n4894.n133 0.0258125
R4856 a_31212_n4894.n133 a_31212_n4894.n131 0.0258125
R4857 a_31212_n4894.n131 a_31212_n4894.n129 0.0258125
R4858 a_31212_n4894.n129 a_31212_n4894.n127 0.0258125
R4859 a_31212_n4894.n127 a_31212_n4894.n125 0.0258125
R4860 a_31212_n4894.n125 a_31212_n4894.n123 0.0258125
R4861 a_31212_n4894.n123 a_31212_n4894.n544 0.089375
R4862 a_31212_n4894.n544 a_31212_n4894.n121 0.0539375
R4863 a_31212_n4894.n121 a_31212_n4894.n119 0.0258125
R4864 a_31212_n4894.n119 a_31212_n4894.n117 0.0258125
R4865 a_31212_n4894.n117 a_31212_n4894.n115 0.0258125
R4866 a_31212_n4894.n115 a_31212_n4894.n113 0.0258125
R4867 a_31212_n4894.n113 a_31212_n4894.n111 0.0258125
R4868 a_31212_n4894.n111 a_31212_n4894.n109 0.0258125
R4869 a_31212_n4894.n109 a_31212_n4894.n107 0.0258125
R4870 a_31212_n4894.n107 a_31212_n4894.n105 0.0258125
R4871 a_31212_n4894.n105 a_31212_n4894.n103 0.0258125
R4872 a_31212_n4894.n103 a_31212_n4894.n101 0.0258125
R4873 a_31212_n4894.n101 a_31212_n4894.n99 0.0258125
R4874 a_31212_n4894.n99 a_31212_n4894.n97 0.0258125
R4875 a_31212_n4894.n97 a_31212_n4894.n95 0.0258125
R4876 a_31212_n4894.n95 a_31212_n4894.n93 0.0258125
R4877 a_31212_n4894.n93 a_31212_n4894.n91 0.0258125
R4878 a_31212_n4894.n91 a_31212_n4894.n89 0.0258125
R4879 a_31212_n4894.n89 a_31212_n4894.n87 0.0258125
R4880 a_31212_n4894.n87 a_31212_n4894.n85 0.0258125
R4881 a_31212_n4894.n85 a_31212_n4894.n83 0.0258125
R4882 a_31212_n4894.n83 a_31212_n4894.n81 0.0258125
R4883 a_31212_n4894.n81 a_31212_n4894.n79 0.0258125
R4884 a_31212_n4894.n79 a_31212_n4894.n77 0.0258125
R4885 a_31212_n4894.n77 a_31212_n4894.n75 0.0258125
R4886 a_31212_n4894.n75 a_31212_n4894.n73 0.0258125
R4887 a_31212_n4894.n73 a_31212_n4894.n71 0.0258125
R4888 a_31212_n4894.n71 a_31212_n4894.n69 0.0258125
R4889 a_31212_n4894.n69 a_31212_n4894.n67 0.0258125
R4890 a_31212_n4894.n67 a_31212_n4894.n65 0.0258125
R4891 a_31212_n4894.n65 a_31212_n4894.n63 0.0258125
R4892 a_31212_n4894.n63 a_31212_n4894.n543 0.089375
R4893 a_31212_n4894.n543 a_31212_n4894.n61 0.0539375
R4894 a_31212_n4894.n61 a_31212_n4894.n59 0.0258125
R4895 a_31212_n4894.n59 a_31212_n4894.n57 0.0258125
R4896 a_31212_n4894.n57 a_31212_n4894.n55 0.0258125
R4897 a_31212_n4894.n55 a_31212_n4894.n53 0.0258125
R4898 a_31212_n4894.n53 a_31212_n4894.n51 0.0258125
R4899 a_31212_n4894.n51 a_31212_n4894.n49 0.0258125
R4900 a_31212_n4894.n49 a_31212_n4894.n47 0.0258125
R4901 a_31212_n4894.n47 a_31212_n4894.n45 0.0258125
R4902 a_31212_n4894.n45 a_31212_n4894.n43 0.0258125
R4903 a_31212_n4894.n43 a_31212_n4894.n41 0.0258125
R4904 a_31212_n4894.n41 a_31212_n4894.n39 0.0258125
R4905 a_31212_n4894.n39 a_31212_n4894.n37 0.0258125
R4906 a_31212_n4894.n37 a_31212_n4894.n35 0.0258125
R4907 a_31212_n4894.n35 a_31212_n4894.n33 0.0258125
R4908 a_31212_n4894.n33 a_31212_n4894.n31 0.0258125
R4909 a_31212_n4894.n31 a_31212_n4894.n29 0.0258125
R4910 a_31212_n4894.n29 a_31212_n4894.n27 0.0258125
R4911 a_31212_n4894.n27 a_31212_n4894.n25 0.0258125
R4912 a_31212_n4894.n25 a_31212_n4894.n23 0.0258125
R4913 a_31212_n4894.n23 a_31212_n4894.n21 0.0258125
R4914 a_31212_n4894.n21 a_31212_n4894.n19 0.0258125
R4915 a_31212_n4894.n19 a_31212_n4894.n17 0.0258125
R4916 a_31212_n4894.n17 a_31212_n4894.n15 0.0258125
R4917 a_31212_n4894.n15 a_31212_n4894.n13 0.0258125
R4918 a_31212_n4894.n13 a_31212_n4894.n11 0.0258125
R4919 a_31212_n4894.n11 a_31212_n4894.n9 0.0258125
R4920 a_31212_n4894.n9 a_31212_n4894.n7 0.0258125
R4921 a_31212_n4894.n7 a_31212_n4894.n5 0.0258125
R4922 a_31212_n4894.n5 a_31212_n4894.n3 0.0258125
R4923 a_31212_n4894.n546 a_31212_n4894.n630 9.0005
R4924 a_31212_n4894.n547 a_31212_n4894.n635 9.0005
R4925 a_31212_n4894.n546 a_31212_n4894.n547 2.17895
R4926 a_31212_n4894.n772 a_31212_n4894.n546 1.01525
R4927 a_31212_n4894.n641 a_31212_n4894.n760 9.0005
R4928 a_31212_n4894.n642 a_31212_n4894.n766 9.0005
R4929 a_31212_n4894.n772 a_31212_n4894.n771 0.8762
R4930 a_31212_n4894.n771 a_31212_n4894.n642 2.17895
R4931 a_31212_n4894.n642 a_31212_n4894.n641 2.17895
R4932 a_31212_n4894.n641 a_31212_n4894.n754 11.179
R4933 a_31212_n4894.n771 a_31212_n4894.n770 9.0005
R4934 a_31212_n4894.n752 a_31212_n4894.n667 9.0005
R4935 a_31212_n4894.n758 a_31212_n4894.n668 9.0005
R4936 a_31212_n4894.n764 a_31212_n4894.n669 9.0005
R4937 a_31212_n4894.n644 a_31212_n4894.n643 1.6115
R4938 a_31212_n4894.n645 a_31212_n4894.n644 1.6115
R4939 a_31212_n4894.n670 a_31212_n4894.n645 1.28525
R4940 a_31212_n4894.n670 a_31212_n4894.n646 0.32675
R4941 a_31212_n4894.n646 a_31212_n4894.n647 1.6115
R4942 a_31212_n4894.n647 a_31212_n4894.n648 1.6115
R4943 a_31212_n4894.n648 a_31212_n4894.n649 1.6115
R4944 a_31212_n4894.n650 a_31212_n4894.n649 1.6115
R4945 a_31212_n4894.n770 a_31212_n4894.n650 0.24125
R4946 a_31212_n4894.n770 a_31212_n4894.n651 1.37075
R4947 a_31212_n4894.n651 a_31212_n4894.n652 1.6115
R4948 a_31212_n4894.n652 a_31212_n4894.n653 1.6115
R4949 a_31212_n4894.n654 a_31212_n4894.n653 1.6115
R4950 a_31212_n4894.n669 a_31212_n4894.n654 0.80825
R4951 a_31212_n4894.n669 a_31212_n4894.n655 0.80375
R4952 a_31212_n4894.n655 a_31212_n4894.n656 1.6115
R4953 a_31212_n4894.n656 a_31212_n4894.n657 1.6115
R4954 a_31212_n4894.n658 a_31212_n4894.n657 1.6115
R4955 a_31212_n4894.n668 a_31212_n4894.n658 1.37525
R4956 a_31212_n4894.n668 a_31212_n4894.n659 0.23675
R4957 a_31212_n4894.n659 a_31212_n4894.n660 1.6115
R4958 a_31212_n4894.n660 a_31212_n4894.n661 1.6115
R4959 a_31212_n4894.n661 a_31212_n4894.n662 1.6115
R4960 a_31212_n4894.n663 a_31212_n4894.n662 1.6115
R4961 a_31212_n4894.n667 a_31212_n4894.n663 0.33125
R4962 a_31212_n4894.n667 a_31212_n4894.n664 1.28075
R4963 a_31212_n4894.n664 a_31212_n4894.n665 1.6115
R4964 a_31212_n4894.n665 a_31212_n4894.n666 1.6115
R4965 a_31212_n4894.n769 a_31212_n4894.n670 9.0005
R4966 a_31212_n4894.n671 a_31212_n4894.n761 9.0005
R4967 a_31212_n4894.n2 a_31212_n4894.n769 0.8762
R4968 a_31212_n4894.n769 a_31212_n4894.n768 2.17895
R4969 a_31212_n4894.n768 a_31212_n4894.n671 2.17895
R4970 a_31212_n4894.n671 a_31212_n4894.n755 11.179
R4971 a_31212_n4894.n768 a_31212_n4894.n767 9.0005
R4972 a_31212_n4894.n751 a_31212_n4894.n696 9.0005
R4973 a_31212_n4894.n757 a_31212_n4894.n697 9.0005
R4974 a_31212_n4894.n673 a_31212_n4894.n672 1.6115
R4975 a_31212_n4894.n674 a_31212_n4894.n673 1.6115
R4976 a_31212_n4894.n767 a_31212_n4894.n674 1.28525
R4977 a_31212_n4894.n767 a_31212_n4894.n675 0.32675
R4978 a_31212_n4894.n675 a_31212_n4894.n676 1.6115
R4979 a_31212_n4894.n676 a_31212_n4894.n677 1.6115
R4980 a_31212_n4894.n677 a_31212_n4894.n678 1.6115
R4981 a_31212_n4894.n679 a_31212_n4894.n678 1.6115
R4982 a_31212_n4894.n766 a_31212_n4894.n679 0.24125
R4983 a_31212_n4894.n766 a_31212_n4894.n680 1.37075
R4984 a_31212_n4894.n680 a_31212_n4894.n681 1.6115
R4985 a_31212_n4894.n681 a_31212_n4894.n682 1.6115
R4986 a_31212_n4894.n683 a_31212_n4894.n682 1.6115
R4987 a_31212_n4894.n698 a_31212_n4894.n683 0.80825
R4988 a_31212_n4894.n698 a_31212_n4894.n684 0.80375
R4989 a_31212_n4894.n684 a_31212_n4894.n685 1.6115
R4990 a_31212_n4894.n685 a_31212_n4894.n686 1.6115
R4991 a_31212_n4894.n687 a_31212_n4894.n686 1.6115
R4992 a_31212_n4894.n697 a_31212_n4894.n687 1.37525
R4993 a_31212_n4894.n697 a_31212_n4894.n688 0.23675
R4994 a_31212_n4894.n688 a_31212_n4894.n689 1.6115
R4995 a_31212_n4894.n689 a_31212_n4894.n690 1.6115
R4996 a_31212_n4894.n690 a_31212_n4894.n691 1.6115
R4997 a_31212_n4894.n692 a_31212_n4894.n691 1.6115
R4998 a_31212_n4894.n696 a_31212_n4894.n692 0.33125
R4999 a_31212_n4894.n696 a_31212_n4894.n693 1.28075
R5000 a_31212_n4894.n693 a_31212_n4894.n694 1.6115
R5001 a_31212_n4894.n694 a_31212_n4894.n695 1.6115
R5002 a_31212_n4894.n765 a_31212_n4894.n698 9.0005
R5003 a_31212_n4894.n545 a_31212_n4894.n764 0.8762
R5004 a_31212_n4894.n764 a_31212_n4894.n765 2.17895
R5005 a_31212_n4894.n765 a_31212_n4894.n763 2.17895
R5006 a_31212_n4894.n763 a_31212_n4894.n753 11.179
R5007 a_31212_n4894.n763 a_31212_n4894.n762 9.0005
R5008 a_31212_n4894.n750 a_31212_n4894.n723 9.0005
R5009 a_31212_n4894.n700 a_31212_n4894.n699 1.6115
R5010 a_31212_n4894.n701 a_31212_n4894.n700 1.6115
R5011 a_31212_n4894.n761 a_31212_n4894.n701 1.28525
R5012 a_31212_n4894.n761 a_31212_n4894.n702 0.32675
R5013 a_31212_n4894.n702 a_31212_n4894.n703 1.6115
R5014 a_31212_n4894.n703 a_31212_n4894.n704 1.6115
R5015 a_31212_n4894.n704 a_31212_n4894.n705 1.6115
R5016 a_31212_n4894.n706 a_31212_n4894.n705 1.6115
R5017 a_31212_n4894.n760 a_31212_n4894.n706 0.24125
R5018 a_31212_n4894.n760 a_31212_n4894.n707 1.37075
R5019 a_31212_n4894.n707 a_31212_n4894.n708 1.6115
R5020 a_31212_n4894.n708 a_31212_n4894.n709 1.6115
R5021 a_31212_n4894.n710 a_31212_n4894.n709 1.6115
R5022 a_31212_n4894.n762 a_31212_n4894.n710 0.80825
R5023 a_31212_n4894.n762 a_31212_n4894.n711 0.80375
R5024 a_31212_n4894.n711 a_31212_n4894.n712 1.6115
R5025 a_31212_n4894.n712 a_31212_n4894.n713 1.6115
R5026 a_31212_n4894.n714 a_31212_n4894.n713 1.6115
R5027 a_31212_n4894.n724 a_31212_n4894.n714 1.37525
R5028 a_31212_n4894.n724 a_31212_n4894.n715 0.23675
R5029 a_31212_n4894.n715 a_31212_n4894.n716 1.6115
R5030 a_31212_n4894.n716 a_31212_n4894.n717 1.6115
R5031 a_31212_n4894.n717 a_31212_n4894.n718 1.6115
R5032 a_31212_n4894.n719 a_31212_n4894.n718 1.6115
R5033 a_31212_n4894.n723 a_31212_n4894.n719 0.33125
R5034 a_31212_n4894.n723 a_31212_n4894.n720 1.28075
R5035 a_31212_n4894.n720 a_31212_n4894.n721 1.6115
R5036 a_31212_n4894.n721 a_31212_n4894.n722 1.6115
R5037 a_31212_n4894.n759 a_31212_n4894.n724 9.0005
R5038 a_31212_n4894.n544 a_31212_n4894.n758 0.8762
R5039 a_31212_n4894.n758 a_31212_n4894.n757 2.17895
R5040 a_31212_n4894.n757 a_31212_n4894.n759 2.17895
R5041 a_31212_n4894.n759 a_31212_n4894.n756 11.179
R5042 a_31212_n4894.n726 a_31212_n4894.n725 1.6115
R5043 a_31212_n4894.n727 a_31212_n4894.n726 1.6115
R5044 a_31212_n4894.n755 a_31212_n4894.n727 1.28525
R5045 a_31212_n4894.n755 a_31212_n4894.n728 0.32675
R5046 a_31212_n4894.n728 a_31212_n4894.n729 1.6115
R5047 a_31212_n4894.n729 a_31212_n4894.n730 1.6115
R5048 a_31212_n4894.n730 a_31212_n4894.n731 1.6115
R5049 a_31212_n4894.n732 a_31212_n4894.n731 1.6115
R5050 a_31212_n4894.n754 a_31212_n4894.n732 0.24125
R5051 a_31212_n4894.n754 a_31212_n4894.n733 1.37075
R5052 a_31212_n4894.n733 a_31212_n4894.n734 1.6115
R5053 a_31212_n4894.n734 a_31212_n4894.n735 1.6115
R5054 a_31212_n4894.n736 a_31212_n4894.n735 1.6115
R5055 a_31212_n4894.n753 a_31212_n4894.n736 0.80825
R5056 a_31212_n4894.n753 a_31212_n4894.n737 0.80375
R5057 a_31212_n4894.n737 a_31212_n4894.n738 1.6115
R5058 a_31212_n4894.n738 a_31212_n4894.n739 1.6115
R5059 a_31212_n4894.n740 a_31212_n4894.n739 1.6115
R5060 a_31212_n4894.n756 a_31212_n4894.n740 1.37525
R5061 a_31212_n4894.n756 a_31212_n4894.n741 0.23675
R5062 a_31212_n4894.n741 a_31212_n4894.n742 1.6115
R5063 a_31212_n4894.n742 a_31212_n4894.n743 1.6115
R5064 a_31212_n4894.n743 a_31212_n4894.n744 1.6115
R5065 a_31212_n4894.n745 a_31212_n4894.n744 1.6115
R5066 a_31212_n4894.n749 a_31212_n4894.n745 0.33125
R5067 a_31212_n4894.n749 a_31212_n4894.n746 1.28075
R5068 a_31212_n4894.n746 a_31212_n4894.n747 1.6115
R5069 a_31212_n4894.n747 a_31212_n4894.n748 1.6115
R5070 a_31212_n4894.n543 a_31212_n4894.n752 0.8762
R5071 a_31212_n4894.n752 a_31212_n4894.n751 2.17895
R5072 a_31212_n4894.n751 a_31212_n4894.n750 2.17895
R5073 a_31212_n4894.n750 a_31212_n4894.n749 11.179
R5074 a_31212_n4894.n748 a_31212_n4894.t169 12.9814
R5075 a_31212_n4894.n748 a_31212_n4894.t170 11.3704
R5076 a_31212_n4894.n747 a_31212_n4894.t171 11.3704
R5077 a_31212_n4894.n746 a_31212_n4894.t172 11.3704
R5078 a_31212_n4894.n745 a_31212_n4894.t173 11.3704
R5079 a_31212_n4894.n744 a_31212_n4894.t174 11.3704
R5080 a_31212_n4894.n743 a_31212_n4894.t175 11.3704
R5081 a_31212_n4894.n742 a_31212_n4894.t176 11.3704
R5082 a_31212_n4894.n741 a_31212_n4894.t177 11.3704
R5083 a_31212_n4894.n740 a_31212_n4894.t178 11.3704
R5084 a_31212_n4894.n739 a_31212_n4894.t179 11.3704
R5085 a_31212_n4894.n738 a_31212_n4894.t180 11.3704
R5086 a_31212_n4894.n737 a_31212_n4894.t181 11.3704
R5087 a_31212_n4894.n736 a_31212_n4894.t182 11.3704
R5088 a_31212_n4894.n735 a_31212_n4894.t183 11.3704
R5089 a_31212_n4894.n734 a_31212_n4894.t184 11.3704
R5090 a_31212_n4894.n733 a_31212_n4894.t185 11.3704
R5091 a_31212_n4894.n732 a_31212_n4894.t186 11.3704
R5092 a_31212_n4894.n731 a_31212_n4894.t187 11.3704
R5093 a_31212_n4894.n730 a_31212_n4894.t188 11.3704
R5094 a_31212_n4894.n729 a_31212_n4894.t189 11.3704
R5095 a_31212_n4894.n728 a_31212_n4894.t190 11.3704
R5096 a_31212_n4894.n727 a_31212_n4894.t191 11.3704
R5097 a_31212_n4894.n726 a_31212_n4894.t192 11.3704
R5098 a_31212_n4894.n725 a_31212_n4894.t193 11.3704
R5099 a_31212_n4894.n725 a_31212_n4894.t194 12.9814
R5100 a_31212_n4894.n722 a_31212_n4894.t143 12.9814
R5101 a_31212_n4894.n722 a_31212_n4894.t144 11.3704
R5102 a_31212_n4894.n721 a_31212_n4894.t145 11.3704
R5103 a_31212_n4894.n720 a_31212_n4894.t146 11.3704
R5104 a_31212_n4894.n719 a_31212_n4894.t147 11.3704
R5105 a_31212_n4894.n718 a_31212_n4894.t148 11.3704
R5106 a_31212_n4894.n717 a_31212_n4894.t149 11.3704
R5107 a_31212_n4894.n716 a_31212_n4894.t150 11.3704
R5108 a_31212_n4894.n715 a_31212_n4894.t151 11.3704
R5109 a_31212_n4894.n714 a_31212_n4894.t152 11.3704
R5110 a_31212_n4894.n713 a_31212_n4894.t153 11.3704
R5111 a_31212_n4894.n712 a_31212_n4894.t154 11.3704
R5112 a_31212_n4894.n711 a_31212_n4894.t155 11.3704
R5113 a_31212_n4894.n710 a_31212_n4894.t156 11.3704
R5114 a_31212_n4894.n709 a_31212_n4894.t157 11.3704
R5115 a_31212_n4894.n708 a_31212_n4894.t158 11.3704
R5116 a_31212_n4894.n707 a_31212_n4894.t159 11.3704
R5117 a_31212_n4894.n706 a_31212_n4894.t160 11.3704
R5118 a_31212_n4894.n705 a_31212_n4894.t161 11.3704
R5119 a_31212_n4894.n704 a_31212_n4894.t162 11.3704
R5120 a_31212_n4894.n703 a_31212_n4894.t163 11.3704
R5121 a_31212_n4894.n702 a_31212_n4894.t164 11.3704
R5122 a_31212_n4894.n701 a_31212_n4894.t165 11.3704
R5123 a_31212_n4894.n700 a_31212_n4894.t166 11.3704
R5124 a_31212_n4894.n699 a_31212_n4894.t167 11.3704
R5125 a_31212_n4894.n699 a_31212_n4894.t168 12.9814
R5126 a_31212_n4894.n695 a_31212_n4894.t117 12.9814
R5127 a_31212_n4894.n695 a_31212_n4894.t118 11.3704
R5128 a_31212_n4894.n694 a_31212_n4894.t119 11.3704
R5129 a_31212_n4894.n693 a_31212_n4894.t120 11.3704
R5130 a_31212_n4894.n692 a_31212_n4894.t121 11.3704
R5131 a_31212_n4894.n691 a_31212_n4894.t122 11.3704
R5132 a_31212_n4894.n690 a_31212_n4894.t123 11.3704
R5133 a_31212_n4894.n689 a_31212_n4894.t124 11.3704
R5134 a_31212_n4894.n688 a_31212_n4894.t125 11.3704
R5135 a_31212_n4894.n687 a_31212_n4894.t126 11.3704
R5136 a_31212_n4894.n686 a_31212_n4894.t127 11.3704
R5137 a_31212_n4894.n685 a_31212_n4894.t128 11.3704
R5138 a_31212_n4894.n684 a_31212_n4894.t129 11.3704
R5139 a_31212_n4894.n683 a_31212_n4894.t130 11.3704
R5140 a_31212_n4894.n682 a_31212_n4894.t131 11.3704
R5141 a_31212_n4894.n681 a_31212_n4894.t132 11.3704
R5142 a_31212_n4894.n680 a_31212_n4894.t133 11.3704
R5143 a_31212_n4894.n679 a_31212_n4894.t134 11.3704
R5144 a_31212_n4894.n678 a_31212_n4894.t135 11.3704
R5145 a_31212_n4894.n677 a_31212_n4894.t136 11.3704
R5146 a_31212_n4894.n676 a_31212_n4894.t137 11.3704
R5147 a_31212_n4894.n675 a_31212_n4894.t138 11.3704
R5148 a_31212_n4894.n674 a_31212_n4894.t139 11.3704
R5149 a_31212_n4894.n673 a_31212_n4894.t140 11.3704
R5150 a_31212_n4894.n672 a_31212_n4894.t141 11.3704
R5151 a_31212_n4894.n672 a_31212_n4894.t142 12.9814
R5152 a_31212_n4894.n666 a_31212_n4894.t91 12.9814
R5153 a_31212_n4894.n666 a_31212_n4894.t92 11.3704
R5154 a_31212_n4894.n665 a_31212_n4894.t93 11.3704
R5155 a_31212_n4894.n664 a_31212_n4894.t94 11.3704
R5156 a_31212_n4894.n663 a_31212_n4894.t95 11.3704
R5157 a_31212_n4894.n662 a_31212_n4894.t96 11.3704
R5158 a_31212_n4894.n661 a_31212_n4894.t97 11.3704
R5159 a_31212_n4894.n660 a_31212_n4894.t98 11.3704
R5160 a_31212_n4894.n659 a_31212_n4894.t99 11.3704
R5161 a_31212_n4894.n658 a_31212_n4894.t100 11.3704
R5162 a_31212_n4894.n657 a_31212_n4894.t101 11.3704
R5163 a_31212_n4894.n656 a_31212_n4894.t102 11.3704
R5164 a_31212_n4894.n655 a_31212_n4894.t103 11.3704
R5165 a_31212_n4894.n654 a_31212_n4894.t104 11.3704
R5166 a_31212_n4894.n653 a_31212_n4894.t105 11.3704
R5167 a_31212_n4894.n652 a_31212_n4894.t106 11.3704
R5168 a_31212_n4894.n651 a_31212_n4894.t107 11.3704
R5169 a_31212_n4894.n650 a_31212_n4894.t108 11.3704
R5170 a_31212_n4894.n649 a_31212_n4894.t109 11.3704
R5171 a_31212_n4894.n648 a_31212_n4894.t110 11.3704
R5172 a_31212_n4894.n647 a_31212_n4894.t111 11.3704
R5173 a_31212_n4894.n646 a_31212_n4894.t112 11.3704
R5174 a_31212_n4894.n645 a_31212_n4894.t113 11.3704
R5175 a_31212_n4894.n644 a_31212_n4894.t114 11.3704
R5176 a_31212_n4894.n643 a_31212_n4894.t115 11.3704
R5177 a_31212_n4894.n643 a_31212_n4894.t116 12.9814
R5178 a_31212_n4894.n547 a_31212_n4894.n640 11.179
R5179 a_31212_n4894.n627 a_31212_n4894.n572 11.179
R5180 a_31212_n4894.n634 a_31212_n4894.n573 11.179
R5181 a_31212_n4894.n549 a_31212_n4894.n548 1.6115
R5182 a_31212_n4894.n550 a_31212_n4894.n549 1.6115
R5183 a_31212_n4894.n639 a_31212_n4894.n550 1.28525
R5184 a_31212_n4894.n639 a_31212_n4894.n551 0.32675
R5185 a_31212_n4894.n551 a_31212_n4894.n552 1.6115
R5186 a_31212_n4894.n552 a_31212_n4894.n553 1.6115
R5187 a_31212_n4894.n553 a_31212_n4894.n554 1.6115
R5188 a_31212_n4894.n555 a_31212_n4894.n554 1.6115
R5189 a_31212_n4894.n640 a_31212_n4894.n555 0.24125
R5190 a_31212_n4894.n640 a_31212_n4894.n556 1.37075
R5191 a_31212_n4894.n556 a_31212_n4894.n557 1.6115
R5192 a_31212_n4894.n557 a_31212_n4894.n558 1.6115
R5193 a_31212_n4894.n559 a_31212_n4894.n558 1.6115
R5194 a_31212_n4894.n574 a_31212_n4894.n559 0.80825
R5195 a_31212_n4894.n574 a_31212_n4894.n560 0.80375
R5196 a_31212_n4894.n560 a_31212_n4894.n561 1.6115
R5197 a_31212_n4894.n561 a_31212_n4894.n562 1.6115
R5198 a_31212_n4894.n563 a_31212_n4894.n562 1.6115
R5199 a_31212_n4894.n573 a_31212_n4894.n563 1.37525
R5200 a_31212_n4894.n573 a_31212_n4894.n564 0.23675
R5201 a_31212_n4894.n564 a_31212_n4894.n565 1.6115
R5202 a_31212_n4894.n565 a_31212_n4894.n566 1.6115
R5203 a_31212_n4894.n566 a_31212_n4894.n567 1.6115
R5204 a_31212_n4894.n568 a_31212_n4894.n567 1.6115
R5205 a_31212_n4894.n572 a_31212_n4894.n568 0.33125
R5206 a_31212_n4894.n572 a_31212_n4894.n569 1.28075
R5207 a_31212_n4894.n569 a_31212_n4894.n570 1.6115
R5208 a_31212_n4894.n570 a_31212_n4894.n571 1.6115
R5209 a_31212_n4894.n575 a_31212_n4894.n629 9.0005
R5210 a_31212_n4894.n638 a_31212_n4894.n574 11.179
R5211 a_31212_n4894.n575 a_31212_n4894.n638 2.17895
R5212 a_31212_n4894.n545 a_31212_n4894.n575 1.01525
R5213 a_31212_n4894.n638 a_31212_n4894.n637 9.0005
R5214 a_31212_n4894.n627 a_31212_n4894.n600 9.0005
R5215 a_31212_n4894.n577 a_31212_n4894.n576 1.6115
R5216 a_31212_n4894.n578 a_31212_n4894.n577 1.6115
R5217 a_31212_n4894.n636 a_31212_n4894.n578 1.28525
R5218 a_31212_n4894.n636 a_31212_n4894.n579 0.32675
R5219 a_31212_n4894.n579 a_31212_n4894.n580 1.6115
R5220 a_31212_n4894.n580 a_31212_n4894.n581 1.6115
R5221 a_31212_n4894.n581 a_31212_n4894.n582 1.6115
R5222 a_31212_n4894.n583 a_31212_n4894.n582 1.6115
R5223 a_31212_n4894.n635 a_31212_n4894.n583 0.24125
R5224 a_31212_n4894.n635 a_31212_n4894.n584 1.37075
R5225 a_31212_n4894.n584 a_31212_n4894.n585 1.6115
R5226 a_31212_n4894.n585 a_31212_n4894.n586 1.6115
R5227 a_31212_n4894.n587 a_31212_n4894.n586 1.6115
R5228 a_31212_n4894.n637 a_31212_n4894.n587 0.80825
R5229 a_31212_n4894.n637 a_31212_n4894.n588 0.80375
R5230 a_31212_n4894.n588 a_31212_n4894.n589 1.6115
R5231 a_31212_n4894.n589 a_31212_n4894.n590 1.6115
R5232 a_31212_n4894.n591 a_31212_n4894.n590 1.6115
R5233 a_31212_n4894.n601 a_31212_n4894.n591 1.37525
R5234 a_31212_n4894.n601 a_31212_n4894.n592 0.23675
R5235 a_31212_n4894.n592 a_31212_n4894.n593 1.6115
R5236 a_31212_n4894.n593 a_31212_n4894.n594 1.6115
R5237 a_31212_n4894.n594 a_31212_n4894.n595 1.6115
R5238 a_31212_n4894.n596 a_31212_n4894.n595 1.6115
R5239 a_31212_n4894.n600 a_31212_n4894.n596 0.33125
R5240 a_31212_n4894.n600 a_31212_n4894.n597 1.28075
R5241 a_31212_n4894.n597 a_31212_n4894.n598 1.6115
R5242 a_31212_n4894.n598 a_31212_n4894.n599 1.6115
R5243 a_31212_n4894.n634 a_31212_n4894.n601 9.0005
R5244 a_31212_n4894.n633 a_31212_n4894.n634 2.17895
R5245 a_31212_n4894.n544 a_31212_n4894.n633 1.01525
R5246 a_31212_n4894.n633 a_31212_n4894.n632 9.0005
R5247 a_31212_n4894.n603 a_31212_n4894.n602 1.6115
R5248 a_31212_n4894.n604 a_31212_n4894.n603 1.6115
R5249 a_31212_n4894.n631 a_31212_n4894.n604 1.28525
R5250 a_31212_n4894.n631 a_31212_n4894.n605 0.32675
R5251 a_31212_n4894.n605 a_31212_n4894.n606 1.6115
R5252 a_31212_n4894.n606 a_31212_n4894.n607 1.6115
R5253 a_31212_n4894.n607 a_31212_n4894.n608 1.6115
R5254 a_31212_n4894.n609 a_31212_n4894.n608 1.6115
R5255 a_31212_n4894.n630 a_31212_n4894.n609 0.24125
R5256 a_31212_n4894.n630 a_31212_n4894.n610 1.37075
R5257 a_31212_n4894.n610 a_31212_n4894.n611 1.6115
R5258 a_31212_n4894.n611 a_31212_n4894.n612 1.6115
R5259 a_31212_n4894.n613 a_31212_n4894.n612 1.6115
R5260 a_31212_n4894.n629 a_31212_n4894.n613 0.80825
R5261 a_31212_n4894.n629 a_31212_n4894.n614 0.80375
R5262 a_31212_n4894.n614 a_31212_n4894.n615 1.6115
R5263 a_31212_n4894.n615 a_31212_n4894.n616 1.6115
R5264 a_31212_n4894.n617 a_31212_n4894.n616 1.6115
R5265 a_31212_n4894.n632 a_31212_n4894.n617 1.37525
R5266 a_31212_n4894.n632 a_31212_n4894.n618 0.23675
R5267 a_31212_n4894.n618 a_31212_n4894.n619 1.6115
R5268 a_31212_n4894.n619 a_31212_n4894.n620 1.6115
R5269 a_31212_n4894.n620 a_31212_n4894.n621 1.6115
R5270 a_31212_n4894.n622 a_31212_n4894.n621 1.6115
R5271 a_31212_n4894.n626 a_31212_n4894.n622 0.33125
R5272 a_31212_n4894.n626 a_31212_n4894.n623 1.28075
R5273 a_31212_n4894.n623 a_31212_n4894.n624 1.6115
R5274 a_31212_n4894.n624 a_31212_n4894.n625 1.6115
R5275 a_31212_n4894.n628 a_31212_n4894.n626 9.0005
R5276 a_31212_n4894.n628 a_31212_n4894.n627 2.17895
R5277 a_31212_n4894.n543 a_31212_n4894.n628 1.01525
R5278 a_31212_n4894.n625 a_31212_n4894.t65 12.9814
R5279 a_31212_n4894.n625 a_31212_n4894.t66 11.3704
R5280 a_31212_n4894.n624 a_31212_n4894.t67 11.3704
R5281 a_31212_n4894.n623 a_31212_n4894.t68 11.3704
R5282 a_31212_n4894.n622 a_31212_n4894.t69 11.3704
R5283 a_31212_n4894.n621 a_31212_n4894.t70 11.3704
R5284 a_31212_n4894.n620 a_31212_n4894.t71 11.3704
R5285 a_31212_n4894.n619 a_31212_n4894.t72 11.3704
R5286 a_31212_n4894.n618 a_31212_n4894.t73 11.3704
R5287 a_31212_n4894.n617 a_31212_n4894.t74 11.3704
R5288 a_31212_n4894.n616 a_31212_n4894.t75 11.3704
R5289 a_31212_n4894.n615 a_31212_n4894.t76 11.3704
R5290 a_31212_n4894.n614 a_31212_n4894.t77 11.3704
R5291 a_31212_n4894.n613 a_31212_n4894.t78 11.3704
R5292 a_31212_n4894.n612 a_31212_n4894.t79 11.3704
R5293 a_31212_n4894.n611 a_31212_n4894.t80 11.3704
R5294 a_31212_n4894.n610 a_31212_n4894.t81 11.3704
R5295 a_31212_n4894.n609 a_31212_n4894.t82 11.3704
R5296 a_31212_n4894.n608 a_31212_n4894.t83 11.3704
R5297 a_31212_n4894.n607 a_31212_n4894.t84 11.3704
R5298 a_31212_n4894.n606 a_31212_n4894.t85 11.3704
R5299 a_31212_n4894.n605 a_31212_n4894.t86 11.3704
R5300 a_31212_n4894.n604 a_31212_n4894.t87 11.3704
R5301 a_31212_n4894.n603 a_31212_n4894.t88 11.3704
R5302 a_31212_n4894.n602 a_31212_n4894.t89 11.3704
R5303 a_31212_n4894.n602 a_31212_n4894.t90 12.9814
R5304 a_31212_n4894.n599 a_31212_n4894.t39 12.9814
R5305 a_31212_n4894.n599 a_31212_n4894.t40 11.3704
R5306 a_31212_n4894.n598 a_31212_n4894.t41 11.3704
R5307 a_31212_n4894.n597 a_31212_n4894.t42 11.3704
R5308 a_31212_n4894.n596 a_31212_n4894.t43 11.3704
R5309 a_31212_n4894.n595 a_31212_n4894.t44 11.3704
R5310 a_31212_n4894.n594 a_31212_n4894.t45 11.3704
R5311 a_31212_n4894.n593 a_31212_n4894.t46 11.3704
R5312 a_31212_n4894.n592 a_31212_n4894.t47 11.3704
R5313 a_31212_n4894.n591 a_31212_n4894.t48 11.3704
R5314 a_31212_n4894.n590 a_31212_n4894.t49 11.3704
R5315 a_31212_n4894.n589 a_31212_n4894.t50 11.3704
R5316 a_31212_n4894.n588 a_31212_n4894.t51 11.3704
R5317 a_31212_n4894.n587 a_31212_n4894.t52 11.3704
R5318 a_31212_n4894.n586 a_31212_n4894.t53 11.3704
R5319 a_31212_n4894.n585 a_31212_n4894.t54 11.3704
R5320 a_31212_n4894.n584 a_31212_n4894.t55 11.3704
R5321 a_31212_n4894.n583 a_31212_n4894.t56 11.3704
R5322 a_31212_n4894.n582 a_31212_n4894.t57 11.3704
R5323 a_31212_n4894.n581 a_31212_n4894.t58 11.3704
R5324 a_31212_n4894.n580 a_31212_n4894.t59 11.3704
R5325 a_31212_n4894.n579 a_31212_n4894.t60 11.3704
R5326 a_31212_n4894.n578 a_31212_n4894.t61 11.3704
R5327 a_31212_n4894.n577 a_31212_n4894.t62 11.3704
R5328 a_31212_n4894.n576 a_31212_n4894.t63 11.3704
R5329 a_31212_n4894.n576 a_31212_n4894.t64 12.9814
R5330 a_31212_n4894.n571 a_31212_n4894.t13 12.9814
R5331 a_31212_n4894.n571 a_31212_n4894.t14 11.3704
R5332 a_31212_n4894.n570 a_31212_n4894.t15 11.3704
R5333 a_31212_n4894.n569 a_31212_n4894.t16 11.3704
R5334 a_31212_n4894.n568 a_31212_n4894.t17 11.3704
R5335 a_31212_n4894.n567 a_31212_n4894.t18 11.3704
R5336 a_31212_n4894.n566 a_31212_n4894.t19 11.3704
R5337 a_31212_n4894.n565 a_31212_n4894.t20 11.3704
R5338 a_31212_n4894.n564 a_31212_n4894.t21 11.3704
R5339 a_31212_n4894.n563 a_31212_n4894.t22 11.3704
R5340 a_31212_n4894.n562 a_31212_n4894.t23 11.3704
R5341 a_31212_n4894.n561 a_31212_n4894.t24 11.3704
R5342 a_31212_n4894.n560 a_31212_n4894.t25 11.3704
R5343 a_31212_n4894.n559 a_31212_n4894.t26 11.3704
R5344 a_31212_n4894.n558 a_31212_n4894.t27 11.3704
R5345 a_31212_n4894.n557 a_31212_n4894.t28 11.3704
R5346 a_31212_n4894.n556 a_31212_n4894.t29 11.3704
R5347 a_31212_n4894.n555 a_31212_n4894.t30 11.3704
R5348 a_31212_n4894.n554 a_31212_n4894.t31 11.3704
R5349 a_31212_n4894.n553 a_31212_n4894.t32 11.3704
R5350 a_31212_n4894.n552 a_31212_n4894.t33 11.3704
R5351 a_31212_n4894.n551 a_31212_n4894.t34 11.3704
R5352 a_31212_n4894.n550 a_31212_n4894.t35 11.3704
R5353 a_31212_n4894.n549 a_31212_n4894.t36 11.3704
R5354 a_31212_n4894.n548 a_31212_n4894.t37 11.3704
R5355 a_31212_n4894.n548 a_31212_n4894.t38 12.9814
R5356 a_31212_n4894.n542 a_31212_n4894.n541 0.0390714
R5357 a_31212_n4894.n541 a_31212_n4894.n540 0.0390714
R5358 a_31212_n4894.n540 a_31212_n4894.n539 0.0390714
R5359 a_31212_n4894.n539 a_31212_n4894.n538 0.0390714
R5360 a_31212_n4894.n538 a_31212_n4894.n537 0.0390714
R5361 a_31212_n4894.n537 a_31212_n4894.n536 0.0390714
R5362 a_31212_n4894.n536 a_31212_n4894.n535 0.0390714
R5363 a_31212_n4894.n535 a_31212_n4894.n534 0.0390714
R5364 a_31212_n4894.n534 a_31212_n4894.n533 0.0390714
R5365 a_31212_n4894.n533 a_31212_n4894.n532 0.0390714
R5366 a_31212_n4894.n532 a_31212_n4894.n531 0.0390714
R5367 a_31212_n4894.n531 a_31212_n4894.n530 0.0390714
R5368 a_31212_n4894.n530 a_31212_n4894.n529 0.0390714
R5369 a_31212_n4894.n529 a_31212_n4894.n528 0.0390714
R5370 a_31212_n4894.n528 a_31212_n4894.n527 0.0390714
R5371 a_31212_n4894.n527 a_31212_n4894.t1 0.00821429
R5372 a_31212_n4894.n526 a_31212_n4894.t1 0.0313571
R5373 a_31212_n4894.n526 a_31212_n4894.n525 0.0390714
R5374 a_31212_n4894.n525 a_31212_n4894.n524 0.0390714
R5375 a_31212_n4894.n524 a_31212_n4894.n523 0.0390714
R5376 a_31212_n4894.n523 a_31212_n4894.n522 0.0390714
R5377 a_31212_n4894.n522 a_31212_n4894.n521 0.0390714
R5378 a_31212_n4894.n521 a_31212_n4894.n520 0.0390714
R5379 a_31212_n4894.n520 a_31212_n4894.n519 0.0390714
R5380 a_31212_n4894.n519 a_31212_n4894.n518 0.0390714
R5381 a_31212_n4894.n518 a_31212_n4894.n517 0.0390714
R5382 a_31212_n4894.n517 a_31212_n4894.n516 0.0390714
R5383 a_31212_n4894.n516 a_31212_n4894.n515 0.0390714
R5384 a_31212_n4894.n515 a_31212_n4894.n514 0.0390714
R5385 a_31212_n4894.n514 a_31212_n4894.n513 0.0390714
R5386 a_31212_n4894.n542 a_31212_n4894.t1 6.0785
R5387 a_31212_n4894.n513 a_31212_n4894.t1 6.1325
R5388 a_31212_n4894.n512 a_31212_n4894.n511 0.0390714
R5389 a_31212_n4894.n511 a_31212_n4894.n510 0.0390714
R5390 a_31212_n4894.n510 a_31212_n4894.n509 0.0390714
R5391 a_31212_n4894.n509 a_31212_n4894.n508 0.0390714
R5392 a_31212_n4894.n508 a_31212_n4894.n507 0.0390714
R5393 a_31212_n4894.n507 a_31212_n4894.n506 0.0390714
R5394 a_31212_n4894.n506 a_31212_n4894.n505 0.0390714
R5395 a_31212_n4894.n505 a_31212_n4894.n504 0.0390714
R5396 a_31212_n4894.n504 a_31212_n4894.n503 0.0390714
R5397 a_31212_n4894.n503 a_31212_n4894.n502 0.0390714
R5398 a_31212_n4894.n502 a_31212_n4894.n501 0.0390714
R5399 a_31212_n4894.n501 a_31212_n4894.n500 0.0390714
R5400 a_31212_n4894.n500 a_31212_n4894.n499 0.0390714
R5401 a_31212_n4894.n499 a_31212_n4894.n498 0.0390714
R5402 a_31212_n4894.n498 a_31212_n4894.n497 0.0390714
R5403 a_31212_n4894.n497 a_31212_n4894.t2 0.00821429
R5404 a_31212_n4894.t2 a_31212_n4894.n496 0.0313571
R5405 a_31212_n4894.n496 a_31212_n4894.n495 0.0390714
R5406 a_31212_n4894.n495 a_31212_n4894.n494 0.0390714
R5407 a_31212_n4894.n494 a_31212_n4894.n493 0.0390714
R5408 a_31212_n4894.n493 a_31212_n4894.n492 0.0390714
R5409 a_31212_n4894.n492 a_31212_n4894.n491 0.0390714
R5410 a_31212_n4894.n491 a_31212_n4894.n490 0.0390714
R5411 a_31212_n4894.n490 a_31212_n4894.n489 0.0390714
R5412 a_31212_n4894.n489 a_31212_n4894.n488 0.0390714
R5413 a_31212_n4894.n488 a_31212_n4894.n487 0.0390714
R5414 a_31212_n4894.n487 a_31212_n4894.n486 0.0390714
R5415 a_31212_n4894.n486 a_31212_n4894.n485 0.0390714
R5416 a_31212_n4894.n485 a_31212_n4894.n484 0.0390714
R5417 a_31212_n4894.n484 a_31212_n4894.n483 0.0390714
R5418 a_31212_n4894.n512 a_31212_n4894.t2 6.0785
R5419 a_31212_n4894.n483 a_31212_n4894.t2 6.1325
R5420 a_31212_n4894.n482 a_31212_n4894.n481 0.0390714
R5421 a_31212_n4894.n481 a_31212_n4894.n480 0.0390714
R5422 a_31212_n4894.n480 a_31212_n4894.n479 0.0390714
R5423 a_31212_n4894.n479 a_31212_n4894.n478 0.0390714
R5424 a_31212_n4894.n478 a_31212_n4894.n477 0.0390714
R5425 a_31212_n4894.n477 a_31212_n4894.n476 0.0390714
R5426 a_31212_n4894.n476 a_31212_n4894.n475 0.0390714
R5427 a_31212_n4894.n475 a_31212_n4894.n474 0.0390714
R5428 a_31212_n4894.n474 a_31212_n4894.n473 0.0390714
R5429 a_31212_n4894.n473 a_31212_n4894.n472 0.0390714
R5430 a_31212_n4894.n472 a_31212_n4894.n471 0.0390714
R5431 a_31212_n4894.n471 a_31212_n4894.n470 0.0390714
R5432 a_31212_n4894.n470 a_31212_n4894.n469 0.0390714
R5433 a_31212_n4894.n469 a_31212_n4894.n468 0.0390714
R5434 a_31212_n4894.n468 a_31212_n4894.n467 0.0390714
R5435 a_31212_n4894.n467 a_31212_n4894.t3 0.00821429
R5436 a_31212_n4894.t3 a_31212_n4894.n466 0.0313571
R5437 a_31212_n4894.n466 a_31212_n4894.n465 0.0390714
R5438 a_31212_n4894.n465 a_31212_n4894.n464 0.0390714
R5439 a_31212_n4894.n464 a_31212_n4894.n463 0.0390714
R5440 a_31212_n4894.n463 a_31212_n4894.n462 0.0390714
R5441 a_31212_n4894.n462 a_31212_n4894.n461 0.0390714
R5442 a_31212_n4894.n461 a_31212_n4894.n460 0.0390714
R5443 a_31212_n4894.n460 a_31212_n4894.n459 0.0390714
R5444 a_31212_n4894.n459 a_31212_n4894.n458 0.0390714
R5445 a_31212_n4894.n458 a_31212_n4894.n457 0.0390714
R5446 a_31212_n4894.n457 a_31212_n4894.n456 0.0390714
R5447 a_31212_n4894.n456 a_31212_n4894.n455 0.0390714
R5448 a_31212_n4894.n455 a_31212_n4894.n454 0.0390714
R5449 a_31212_n4894.n454 a_31212_n4894.n453 0.0390714
R5450 a_31212_n4894.n482 a_31212_n4894.t3 6.0785
R5451 a_31212_n4894.n453 a_31212_n4894.t3 6.1325
R5452 a_31212_n4894.n452 a_31212_n4894.n451 0.0390714
R5453 a_31212_n4894.n451 a_31212_n4894.n450 0.0390714
R5454 a_31212_n4894.n450 a_31212_n4894.n449 0.0390714
R5455 a_31212_n4894.n449 a_31212_n4894.n448 0.0390714
R5456 a_31212_n4894.n448 a_31212_n4894.n447 0.0390714
R5457 a_31212_n4894.n447 a_31212_n4894.n446 0.0390714
R5458 a_31212_n4894.n446 a_31212_n4894.n445 0.0390714
R5459 a_31212_n4894.n445 a_31212_n4894.n444 0.0390714
R5460 a_31212_n4894.n444 a_31212_n4894.n443 0.0390714
R5461 a_31212_n4894.n443 a_31212_n4894.n442 0.0390714
R5462 a_31212_n4894.n442 a_31212_n4894.n441 0.0390714
R5463 a_31212_n4894.n441 a_31212_n4894.n440 0.0390714
R5464 a_31212_n4894.n440 a_31212_n4894.n439 0.0390714
R5465 a_31212_n4894.n439 a_31212_n4894.n438 0.0390714
R5466 a_31212_n4894.n438 a_31212_n4894.n437 0.0390714
R5467 a_31212_n4894.n437 a_31212_n4894.t4 0.00821429
R5468 a_31212_n4894.t4 a_31212_n4894.n436 0.0313571
R5469 a_31212_n4894.n436 a_31212_n4894.n435 0.0390714
R5470 a_31212_n4894.n435 a_31212_n4894.n434 0.0390714
R5471 a_31212_n4894.n434 a_31212_n4894.n433 0.0390714
R5472 a_31212_n4894.n433 a_31212_n4894.n432 0.0390714
R5473 a_31212_n4894.n432 a_31212_n4894.n431 0.0390714
R5474 a_31212_n4894.n431 a_31212_n4894.n430 0.0390714
R5475 a_31212_n4894.n430 a_31212_n4894.n429 0.0390714
R5476 a_31212_n4894.n429 a_31212_n4894.n428 0.0390714
R5477 a_31212_n4894.n428 a_31212_n4894.n427 0.0390714
R5478 a_31212_n4894.n427 a_31212_n4894.n426 0.0390714
R5479 a_31212_n4894.n426 a_31212_n4894.n425 0.0390714
R5480 a_31212_n4894.n425 a_31212_n4894.n424 0.0390714
R5481 a_31212_n4894.n424 a_31212_n4894.n423 0.0390714
R5482 a_31212_n4894.n452 a_31212_n4894.t4 6.0785
R5483 a_31212_n4894.n423 a_31212_n4894.t4 6.1325
R5484 a_31212_n4894.n422 a_31212_n4894.n421 0.0390714
R5485 a_31212_n4894.n421 a_31212_n4894.n420 0.0390714
R5486 a_31212_n4894.n420 a_31212_n4894.n419 0.0390714
R5487 a_31212_n4894.n419 a_31212_n4894.n418 0.0390714
R5488 a_31212_n4894.n418 a_31212_n4894.n417 0.0390714
R5489 a_31212_n4894.n417 a_31212_n4894.n416 0.0390714
R5490 a_31212_n4894.n416 a_31212_n4894.n415 0.0390714
R5491 a_31212_n4894.n415 a_31212_n4894.n414 0.0390714
R5492 a_31212_n4894.n414 a_31212_n4894.n413 0.0390714
R5493 a_31212_n4894.n413 a_31212_n4894.n412 0.0390714
R5494 a_31212_n4894.n412 a_31212_n4894.n411 0.0390714
R5495 a_31212_n4894.n411 a_31212_n4894.n410 0.0390714
R5496 a_31212_n4894.n410 a_31212_n4894.n409 0.0390714
R5497 a_31212_n4894.n409 a_31212_n4894.n408 0.0390714
R5498 a_31212_n4894.n408 a_31212_n4894.n407 0.0390714
R5499 a_31212_n4894.n407 a_31212_n4894.t5 0.00821429
R5500 a_31212_n4894.t5 a_31212_n4894.n406 0.0313571
R5501 a_31212_n4894.n406 a_31212_n4894.n405 0.0390714
R5502 a_31212_n4894.n405 a_31212_n4894.n404 0.0390714
R5503 a_31212_n4894.n404 a_31212_n4894.n403 0.0390714
R5504 a_31212_n4894.n403 a_31212_n4894.n402 0.0390714
R5505 a_31212_n4894.n402 a_31212_n4894.n401 0.0390714
R5506 a_31212_n4894.n401 a_31212_n4894.n400 0.0390714
R5507 a_31212_n4894.n400 a_31212_n4894.n399 0.0390714
R5508 a_31212_n4894.n399 a_31212_n4894.n398 0.0390714
R5509 a_31212_n4894.n398 a_31212_n4894.n397 0.0390714
R5510 a_31212_n4894.n397 a_31212_n4894.n396 0.0390714
R5511 a_31212_n4894.n396 a_31212_n4894.n395 0.0390714
R5512 a_31212_n4894.n395 a_31212_n4894.n394 0.0390714
R5513 a_31212_n4894.n394 a_31212_n4894.n393 0.0390714
R5514 a_31212_n4894.n422 a_31212_n4894.t5 6.0785
R5515 a_31212_n4894.n393 a_31212_n4894.t5 6.1325
R5516 a_31212_n4894.n392 a_31212_n4894.n391 0.0390714
R5517 a_31212_n4894.n391 a_31212_n4894.n390 0.0390714
R5518 a_31212_n4894.n390 a_31212_n4894.n389 0.0390714
R5519 a_31212_n4894.n389 a_31212_n4894.n388 0.0390714
R5520 a_31212_n4894.n388 a_31212_n4894.n387 0.0390714
R5521 a_31212_n4894.n387 a_31212_n4894.n386 0.0390714
R5522 a_31212_n4894.n386 a_31212_n4894.n385 0.0390714
R5523 a_31212_n4894.n385 a_31212_n4894.n384 0.0390714
R5524 a_31212_n4894.n384 a_31212_n4894.n383 0.0390714
R5525 a_31212_n4894.n383 a_31212_n4894.n382 0.0390714
R5526 a_31212_n4894.n382 a_31212_n4894.n381 0.0390714
R5527 a_31212_n4894.n381 a_31212_n4894.n380 0.0390714
R5528 a_31212_n4894.n380 a_31212_n4894.n379 0.0390714
R5529 a_31212_n4894.n379 a_31212_n4894.n378 0.0390714
R5530 a_31212_n4894.n378 a_31212_n4894.n377 0.0390714
R5531 a_31212_n4894.n377 a_31212_n4894.t6 0.00821429
R5532 a_31212_n4894.t6 a_31212_n4894.n376 0.0313571
R5533 a_31212_n4894.n376 a_31212_n4894.n375 0.0390714
R5534 a_31212_n4894.n375 a_31212_n4894.n374 0.0390714
R5535 a_31212_n4894.n374 a_31212_n4894.n373 0.0390714
R5536 a_31212_n4894.n373 a_31212_n4894.n372 0.0390714
R5537 a_31212_n4894.n372 a_31212_n4894.n371 0.0390714
R5538 a_31212_n4894.n371 a_31212_n4894.n370 0.0390714
R5539 a_31212_n4894.n370 a_31212_n4894.n369 0.0390714
R5540 a_31212_n4894.n369 a_31212_n4894.n368 0.0390714
R5541 a_31212_n4894.n368 a_31212_n4894.n367 0.0390714
R5542 a_31212_n4894.n367 a_31212_n4894.n366 0.0390714
R5543 a_31212_n4894.n366 a_31212_n4894.n365 0.0390714
R5544 a_31212_n4894.n365 a_31212_n4894.n364 0.0390714
R5545 a_31212_n4894.n364 a_31212_n4894.n363 0.0390714
R5546 a_31212_n4894.n392 a_31212_n4894.t6 6.0785
R5547 a_31212_n4894.n363 a_31212_n4894.t6 6.1325
R5548 a_31212_n4894.n362 a_31212_n4894.n360 0.0390714
R5549 a_31212_n4894.n360 a_31212_n4894.n358 0.0390714
R5550 a_31212_n4894.n358 a_31212_n4894.n356 0.0390714
R5551 a_31212_n4894.n356 a_31212_n4894.n354 0.0390714
R5552 a_31212_n4894.n354 a_31212_n4894.n352 0.0390714
R5553 a_31212_n4894.n352 a_31212_n4894.n350 0.0390714
R5554 a_31212_n4894.n350 a_31212_n4894.n348 0.0390714
R5555 a_31212_n4894.n348 a_31212_n4894.n346 0.0390714
R5556 a_31212_n4894.n346 a_31212_n4894.n344 0.0390714
R5557 a_31212_n4894.n344 a_31212_n4894.n342 0.0390714
R5558 a_31212_n4894.n342 a_31212_n4894.n340 0.0390714
R5559 a_31212_n4894.n340 a_31212_n4894.n338 0.0390714
R5560 a_31212_n4894.n338 a_31212_n4894.n336 0.0390714
R5561 a_31212_n4894.n336 a_31212_n4894.n334 0.0390714
R5562 a_31212_n4894.n334 a_31212_n4894.n332 0.0390714
R5563 a_31212_n4894.n332 a_31212_n4894.t7 0.00821429
R5564 a_31212_n4894.n330 a_31212_n4894.t7 0.0313571
R5565 a_31212_n4894.n330 a_31212_n4894.n328 0.0390714
R5566 a_31212_n4894.n328 a_31212_n4894.n326 0.0390714
R5567 a_31212_n4894.n326 a_31212_n4894.n324 0.0390714
R5568 a_31212_n4894.n324 a_31212_n4894.n322 0.0390714
R5569 a_31212_n4894.n322 a_31212_n4894.n320 0.0390714
R5570 a_31212_n4894.n320 a_31212_n4894.n318 0.0390714
R5571 a_31212_n4894.n318 a_31212_n4894.n316 0.0390714
R5572 a_31212_n4894.n316 a_31212_n4894.n314 0.0390714
R5573 a_31212_n4894.n314 a_31212_n4894.n312 0.0390714
R5574 a_31212_n4894.n312 a_31212_n4894.n310 0.0390714
R5575 a_31212_n4894.n310 a_31212_n4894.n308 0.0390714
R5576 a_31212_n4894.n308 a_31212_n4894.n306 0.0390714
R5577 a_31212_n4894.n306 a_31212_n4894.n304 0.0390714
R5578 a_31212_n4894.t7 a_31212_n4894.n304 6.1325
R5579 a_31212_n4894.t7 a_31212_n4894.n362 6.0785
R5580 a_31212_n4894.n302 a_31212_n4894.n300 0.0390714
R5581 a_31212_n4894.n300 a_31212_n4894.n298 0.0390714
R5582 a_31212_n4894.n298 a_31212_n4894.n296 0.0390714
R5583 a_31212_n4894.n296 a_31212_n4894.n294 0.0390714
R5584 a_31212_n4894.n294 a_31212_n4894.n292 0.0390714
R5585 a_31212_n4894.n292 a_31212_n4894.n290 0.0390714
R5586 a_31212_n4894.n290 a_31212_n4894.n288 0.0390714
R5587 a_31212_n4894.n288 a_31212_n4894.n286 0.0390714
R5588 a_31212_n4894.n286 a_31212_n4894.n284 0.0390714
R5589 a_31212_n4894.n284 a_31212_n4894.n282 0.0390714
R5590 a_31212_n4894.n282 a_31212_n4894.n280 0.0390714
R5591 a_31212_n4894.n280 a_31212_n4894.n278 0.0390714
R5592 a_31212_n4894.n278 a_31212_n4894.n276 0.0390714
R5593 a_31212_n4894.n276 a_31212_n4894.n274 0.0390714
R5594 a_31212_n4894.n274 a_31212_n4894.n272 0.0390714
R5595 a_31212_n4894.n272 a_31212_n4894.t8 0.00821429
R5596 a_31212_n4894.t8 a_31212_n4894.n270 0.0313571
R5597 a_31212_n4894.n270 a_31212_n4894.n268 0.0390714
R5598 a_31212_n4894.n268 a_31212_n4894.n266 0.0390714
R5599 a_31212_n4894.n266 a_31212_n4894.n264 0.0390714
R5600 a_31212_n4894.n264 a_31212_n4894.n262 0.0390714
R5601 a_31212_n4894.n262 a_31212_n4894.n260 0.0390714
R5602 a_31212_n4894.n260 a_31212_n4894.n258 0.0390714
R5603 a_31212_n4894.n258 a_31212_n4894.n256 0.0390714
R5604 a_31212_n4894.n256 a_31212_n4894.n254 0.0390714
R5605 a_31212_n4894.n254 a_31212_n4894.n252 0.0390714
R5606 a_31212_n4894.n252 a_31212_n4894.n250 0.0390714
R5607 a_31212_n4894.n250 a_31212_n4894.n248 0.0390714
R5608 a_31212_n4894.n248 a_31212_n4894.n246 0.0390714
R5609 a_31212_n4894.n246 a_31212_n4894.n244 0.0390714
R5610 a_31212_n4894.t8 a_31212_n4894.n244 6.1325
R5611 a_31212_n4894.t8 a_31212_n4894.n302 6.0785
R5612 a_31212_n4894.n242 a_31212_n4894.n240 0.0390714
R5613 a_31212_n4894.n240 a_31212_n4894.n238 0.0390714
R5614 a_31212_n4894.n238 a_31212_n4894.n236 0.0390714
R5615 a_31212_n4894.n236 a_31212_n4894.n234 0.0390714
R5616 a_31212_n4894.n234 a_31212_n4894.n232 0.0390714
R5617 a_31212_n4894.n232 a_31212_n4894.n230 0.0390714
R5618 a_31212_n4894.n230 a_31212_n4894.n228 0.0390714
R5619 a_31212_n4894.n228 a_31212_n4894.n226 0.0390714
R5620 a_31212_n4894.n226 a_31212_n4894.n224 0.0390714
R5621 a_31212_n4894.n224 a_31212_n4894.n222 0.0390714
R5622 a_31212_n4894.n222 a_31212_n4894.n220 0.0390714
R5623 a_31212_n4894.n220 a_31212_n4894.n218 0.0390714
R5624 a_31212_n4894.n218 a_31212_n4894.n216 0.0390714
R5625 a_31212_n4894.n216 a_31212_n4894.n214 0.0390714
R5626 a_31212_n4894.n214 a_31212_n4894.n212 0.0390714
R5627 a_31212_n4894.n212 a_31212_n4894.t9 0.00821429
R5628 a_31212_n4894.t9 a_31212_n4894.n210 0.0313571
R5629 a_31212_n4894.n210 a_31212_n4894.n208 0.0390714
R5630 a_31212_n4894.n208 a_31212_n4894.n206 0.0390714
R5631 a_31212_n4894.n206 a_31212_n4894.n204 0.0390714
R5632 a_31212_n4894.n204 a_31212_n4894.n202 0.0390714
R5633 a_31212_n4894.n202 a_31212_n4894.n200 0.0390714
R5634 a_31212_n4894.n200 a_31212_n4894.n198 0.0390714
R5635 a_31212_n4894.n198 a_31212_n4894.n196 0.0390714
R5636 a_31212_n4894.n196 a_31212_n4894.n194 0.0390714
R5637 a_31212_n4894.n194 a_31212_n4894.n192 0.0390714
R5638 a_31212_n4894.n192 a_31212_n4894.n190 0.0390714
R5639 a_31212_n4894.n190 a_31212_n4894.n188 0.0390714
R5640 a_31212_n4894.n188 a_31212_n4894.n186 0.0390714
R5641 a_31212_n4894.n186 a_31212_n4894.n184 0.0390714
R5642 a_31212_n4894.t9 a_31212_n4894.n184 6.1325
R5643 a_31212_n4894.t9 a_31212_n4894.n242 6.0785
R5644 a_31212_n4894.n182 a_31212_n4894.n180 0.0390714
R5645 a_31212_n4894.n180 a_31212_n4894.n178 0.0390714
R5646 a_31212_n4894.n178 a_31212_n4894.n176 0.0390714
R5647 a_31212_n4894.n176 a_31212_n4894.n174 0.0390714
R5648 a_31212_n4894.n174 a_31212_n4894.n172 0.0390714
R5649 a_31212_n4894.n172 a_31212_n4894.n170 0.0390714
R5650 a_31212_n4894.n170 a_31212_n4894.n168 0.0390714
R5651 a_31212_n4894.n168 a_31212_n4894.n166 0.0390714
R5652 a_31212_n4894.n166 a_31212_n4894.n164 0.0390714
R5653 a_31212_n4894.n164 a_31212_n4894.n162 0.0390714
R5654 a_31212_n4894.n162 a_31212_n4894.n160 0.0390714
R5655 a_31212_n4894.n160 a_31212_n4894.n158 0.0390714
R5656 a_31212_n4894.n158 a_31212_n4894.n156 0.0390714
R5657 a_31212_n4894.n156 a_31212_n4894.n154 0.0390714
R5658 a_31212_n4894.n154 a_31212_n4894.n152 0.0390714
R5659 a_31212_n4894.n152 a_31212_n4894.t10 0.00821429
R5660 a_31212_n4894.t10 a_31212_n4894.n150 0.0313571
R5661 a_31212_n4894.n150 a_31212_n4894.n148 0.0390714
R5662 a_31212_n4894.n148 a_31212_n4894.n146 0.0390714
R5663 a_31212_n4894.n146 a_31212_n4894.n144 0.0390714
R5664 a_31212_n4894.n144 a_31212_n4894.n142 0.0390714
R5665 a_31212_n4894.n142 a_31212_n4894.n140 0.0390714
R5666 a_31212_n4894.n140 a_31212_n4894.n138 0.0390714
R5667 a_31212_n4894.n138 a_31212_n4894.n136 0.0390714
R5668 a_31212_n4894.n136 a_31212_n4894.n134 0.0390714
R5669 a_31212_n4894.n134 a_31212_n4894.n132 0.0390714
R5670 a_31212_n4894.n132 a_31212_n4894.n130 0.0390714
R5671 a_31212_n4894.n130 a_31212_n4894.n128 0.0390714
R5672 a_31212_n4894.n128 a_31212_n4894.n126 0.0390714
R5673 a_31212_n4894.n126 a_31212_n4894.n124 0.0390714
R5674 a_31212_n4894.t10 a_31212_n4894.n124 6.1325
R5675 a_31212_n4894.t10 a_31212_n4894.n182 6.0785
R5676 a_31212_n4894.n122 a_31212_n4894.n120 0.0390714
R5677 a_31212_n4894.n120 a_31212_n4894.n118 0.0390714
R5678 a_31212_n4894.n118 a_31212_n4894.n116 0.0390714
R5679 a_31212_n4894.n116 a_31212_n4894.n114 0.0390714
R5680 a_31212_n4894.n114 a_31212_n4894.n112 0.0390714
R5681 a_31212_n4894.n112 a_31212_n4894.n110 0.0390714
R5682 a_31212_n4894.n110 a_31212_n4894.n108 0.0390714
R5683 a_31212_n4894.n108 a_31212_n4894.n106 0.0390714
R5684 a_31212_n4894.n106 a_31212_n4894.n104 0.0390714
R5685 a_31212_n4894.n104 a_31212_n4894.n102 0.0390714
R5686 a_31212_n4894.n102 a_31212_n4894.n100 0.0390714
R5687 a_31212_n4894.n100 a_31212_n4894.n98 0.0390714
R5688 a_31212_n4894.n98 a_31212_n4894.n96 0.0390714
R5689 a_31212_n4894.n96 a_31212_n4894.n94 0.0390714
R5690 a_31212_n4894.n94 a_31212_n4894.n92 0.0390714
R5691 a_31212_n4894.n92 a_31212_n4894.t11 0.00821429
R5692 a_31212_n4894.t11 a_31212_n4894.n90 0.0313571
R5693 a_31212_n4894.n90 a_31212_n4894.n88 0.0390714
R5694 a_31212_n4894.n88 a_31212_n4894.n86 0.0390714
R5695 a_31212_n4894.n86 a_31212_n4894.n84 0.0390714
R5696 a_31212_n4894.n84 a_31212_n4894.n82 0.0390714
R5697 a_31212_n4894.n82 a_31212_n4894.n80 0.0390714
R5698 a_31212_n4894.n80 a_31212_n4894.n78 0.0390714
R5699 a_31212_n4894.n78 a_31212_n4894.n76 0.0390714
R5700 a_31212_n4894.n76 a_31212_n4894.n74 0.0390714
R5701 a_31212_n4894.n74 a_31212_n4894.n72 0.0390714
R5702 a_31212_n4894.n72 a_31212_n4894.n70 0.0390714
R5703 a_31212_n4894.n70 a_31212_n4894.n68 0.0390714
R5704 a_31212_n4894.n68 a_31212_n4894.n66 0.0390714
R5705 a_31212_n4894.n66 a_31212_n4894.n64 0.0390714
R5706 a_31212_n4894.t11 a_31212_n4894.n64 6.1325
R5707 a_31212_n4894.t11 a_31212_n4894.n122 6.0785
R5708 a_31212_n4894.n62 a_31212_n4894.n60 0.0390714
R5709 a_31212_n4894.n60 a_31212_n4894.n58 0.0390714
R5710 a_31212_n4894.n58 a_31212_n4894.n56 0.0390714
R5711 a_31212_n4894.n56 a_31212_n4894.n54 0.0390714
R5712 a_31212_n4894.n54 a_31212_n4894.n52 0.0390714
R5713 a_31212_n4894.n52 a_31212_n4894.n50 0.0390714
R5714 a_31212_n4894.n50 a_31212_n4894.n48 0.0390714
R5715 a_31212_n4894.n48 a_31212_n4894.n46 0.0390714
R5716 a_31212_n4894.n46 a_31212_n4894.n44 0.0390714
R5717 a_31212_n4894.n44 a_31212_n4894.n42 0.0390714
R5718 a_31212_n4894.n42 a_31212_n4894.n40 0.0390714
R5719 a_31212_n4894.n40 a_31212_n4894.n38 0.0390714
R5720 a_31212_n4894.n38 a_31212_n4894.n36 0.0390714
R5721 a_31212_n4894.n36 a_31212_n4894.n34 0.0390714
R5722 a_31212_n4894.n34 a_31212_n4894.n32 0.0390714
R5723 a_31212_n4894.n32 a_31212_n4894.t12 0.00821429
R5724 a_31212_n4894.t12 a_31212_n4894.n30 0.0313571
R5725 a_31212_n4894.n30 a_31212_n4894.n28 0.0390714
R5726 a_31212_n4894.n28 a_31212_n4894.n26 0.0390714
R5727 a_31212_n4894.n26 a_31212_n4894.n24 0.0390714
R5728 a_31212_n4894.n24 a_31212_n4894.n22 0.0390714
R5729 a_31212_n4894.n22 a_31212_n4894.n20 0.0390714
R5730 a_31212_n4894.n20 a_31212_n4894.n18 0.0390714
R5731 a_31212_n4894.n18 a_31212_n4894.n16 0.0390714
R5732 a_31212_n4894.n16 a_31212_n4894.n14 0.0390714
R5733 a_31212_n4894.n14 a_31212_n4894.n12 0.0390714
R5734 a_31212_n4894.n12 a_31212_n4894.n10 0.0390714
R5735 a_31212_n4894.n10 a_31212_n4894.n8 0.0390714
R5736 a_31212_n4894.n8 a_31212_n4894.n6 0.0390714
R5737 a_31212_n4894.n6 a_31212_n4894.n4 0.0390714
R5738 a_31212_n4894.t12 a_31212_n4894.n4 6.1325
R5739 a_31212_n4894.t12 a_31212_n4894.n62 6.0785
C0 CP_IBIAS TAIL_BIAS 0.12136f
C1 DN TAIL_BIAS 0.09113f
C2 DN CP_IBIAS 0.07452f
C3 UPB CP_IBIAS 0.20728f
C4 REF_1M DN 0.12542f
C5 VCTRL TAIL_BIAS 0.33211f
C6 UPB DN 0.3713f
C7 VDD VDD_VCO 28.1162f
C8 VCTRL CP_IBIAS 0.35309f
C9 UPB REF_1M 0.08086f
C10 FB_1M DN 0.07717f
C11 VDD TAIL_BIAS 3.76533f
C12 m2_11083_1223# VDD_VCO 0.2971f
C13 FB_1M REF_1M 0.68603f
C14 VDD CP_IBIAS 2.33738f
C15 VCTRL DN 0.01289f
C16 m2_11083_1223# TAIL_BIAS 0.2482f
C17 FB_1M UPB 0.27407f
C18 VDD DN 0.31529f
C19 VCTRL UPB 0.01479f
C20 VDD REF_1M 0.20817f
C21 VDD UPB 1.73716f
C22 VDD FB_1M 0.51707f
C23 VDD VCTRL 0.66447f
C24 m2_11083_1223# VDD 1.39859f
C25 m3_n3844_n8846# m3_n2584_n8846# 0.10418f
C26 m2_n1440_5342# VDD 0.59226f
C27 m2_n982_4812# VDD 0.03174f
C28 VDD_VCO VSS 83.48532f
C29 TAIL_BIAS VSS 28.89016f
C30 CP_IBIAS VSS 4.2762f
C31 DN VSS 3.48925f
C32 REF_1M VSS 1.71702f
C33 UPB VSS 3.91888f
C34 FB_1M VSS 1.7326f
C35 VCTRL VSS 30.0844f
C36 VDD VSS 0.33606p
C37 m3_n2584_n8846# VSS 0.17432f $ **FLOATING
C38 m3_n3844_n8846# VSS 0.9652f $ **FLOATING
C39 m3_821_6071# VSS 3.15294f $ **FLOATING
C40 m2_11083_1223# VSS 5.91255f $ **FLOATING
C41 m2_n982_4812# VSS 1.95255f $ **FLOATING
C42 m2_n1440_5342# VSS 0.4832f $ **FLOATING
C43 a_26120_11110.t0 VSS 0.01295f
C44 a_26120_11110.t1 VSS 0.01295f
C45 a_22272_10590.t0 VSS 0.01295f
C46 a_22272_10590.t1 VSS 0.01295f
C47 a_26120_10070.t0 VSS 0.01295f
C48 a_26120_10070.t1 VSS 0.01295f
C49 a_22272_9550.t0 VSS 0.01306f
C50 a_22272_9550.t1 VSS 0.01306f
C51 a_26120_9030.t0 VSS 0.01299f
C52 a_26120_9030.t1 VSS 0.01299f
C53 a_22272_8510.t0 VSS 0.01604f
C54 a_22272_8510.t1 VSS 0.01604f
C55 a_26120_7990.t0 VSS 0.01511f
C56 a_26120_7990.t1 VSS 0.01511f
C57 a_22018_6314.t0 VSS 0.16854f
C58 a_22018_6314.t1 VSS 1.02896f
C59 a_22018_6314.n0 VSS 0.59808f
C60 a_22018_6314.t2 VSS 0.51018f
C61 a_22018_6314.n1 VSS 0.50682f
C62 a_22018_6314.t4 VSS 0.46747f
C63 a_22018_6314.n2 VSS 1.52593f
C64 a_22018_6314.t3 VSS 1.10823f
C65 a_19036_6374.t1 VSS 0.01173f
C66 a_19036_6374.t0 VSS 0.01524f
C67 a_20296_6374.t1 VSS 0.01652f
C68 a_20296_6374.t0 VSS 0.02146f
C69 a_16794_6306.t1 VSS 0.05163f
C70 a_16794_6306.t3 VSS 0.03365f
C71 a_16794_6306.t4 VSS 0.05792f
C72 a_16794_6306.n0 VSS 0.28097f
C73 a_16794_6306.n1 VSS 0.1179f
C74 a_16794_6306.t0 VSS 0.10597f
C75 a_16794_6306.n2 VSS 0.28142f
C76 a_16794_6306.t2 VSS 0.05504f
C77 a_16312_6176.t1 VSS 0.0635f
C78 a_16312_6176.n0 VSS 0.809f
C79 a_16312_6176.t2 VSS 0.13892f
C80 a_16312_6176.t0 VSS 0.12917f
C81 a_18976_6174.t2 VSS 0.04196f
C82 a_18976_6174.n0 VSS 0.19769f
C83 a_18976_6174.t1 VSS 0.07607f
C84 a_18976_6174.t0 VSS 0.15477f
C85 a_18976_6174.t3 VSS 0.15497f
C86 a_18976_6174.n1 VSS 0.24889f
C87 a_15568_5748.t0 VSS 0.01162f
C88 a_15568_5748.n0 VSS 0.08931f
C89 a_15568_5748.t1 VSS 0.07883f
C90 a_15568_5748.t2 VSS 0.01162f
C91 a_17394_5754.t0 VSS 0.01169f
C92 a_17394_5754.n0 VSS 0.08986f
C93 a_17394_5754.t1 VSS 0.07931f
C94 a_17394_5754.t2 VSS 0.01169f
C95 a_3032_n194.t3 VSS 0.05845f
C96 a_3032_n194.n0 VSS 0.037f
C97 a_3032_n194.n1 VSS 0.16864f
C98 a_3032_n194.n2 VSS 0.0125f
C99 a_3032_n194.n47 VSS 0.0125f
C100 a_3032_n194.t0 VSS 0.13702f
C101 a_3032_n194.n49 VSS 0.18448f
C102 a_3032_n194.n50 VSS 0.06172f
C103 a_3032_n194.n51 VSS 0.21685f
C104 a_3032_n194.n52 VSS 0.40061f
C105 a_3032_n194.n53 VSS 0.09685f
C106 a_3032_n194.n54 VSS 0.13738f
C107 a_3032_n194.n55 VSS 0.1993f
C108 a_3032_n194.n56 VSS 0.45824f
C109 a_3032_n194.n57 VSS 0.20568f
C110 a_3032_n194.n58 VSS 0.38435f
C111 a_3032_n194.t6 VSS 35.264f
C112 a_3032_n194.n59 VSS 6.26867f
C113 a_3032_n194.t4 VSS 35.264f
C114 a_3032_n194.n60 VSS 5.8272f
C115 a_3032_n194.t5 VSS 35.264f
C116 a_3032_n194.n61 VSS 6.27522f
C117 a_34356_n5414.t0 VSS 0.01463f
C118 a_34356_n5414.t1 VSS 0.01463f
C119 a_31212_n5934.t0 VSS 0.02264f
C120 a_31212_n5934.t1 VSS 0.02264f
C121 a_34356_n6454.t0 VSS 0.01523f
C122 a_34356_n6454.t1 VSS 0.01523f
C123 a_31212_n6974.t0 VSS 0.019f
C124 a_31212_n6974.t1 VSS 0.019f
C125 a_34356_n7494.t0 VSS 0.01355f
C126 a_34356_n7494.t1 VSS 0.01355f
C127 a_31212_n8014.t0 VSS 0.01855f
C128 a_31212_n8014.t1 VSS 0.01855f
C129 a_34356_n8534.t0 VSS 0.01355f
C130 a_34356_n8534.t1 VSS 0.01355f
C131 a_3336_n8238.t0 VSS 0.5049f
C132 a_3336_n8238.t1 VSS 2.05772f
C133 a_3336_n8238.t4 VSS 1.49328f
C134 a_3336_n8238.t3 VSS 1.49342f
C135 a_3336_n8238.n0 VSS 1.617f
C136 a_3336_n8238.n1 VSS 6.12434f
C137 a_3336_n8238.t2 VSS 0.72051f
C138 a_3336_n8238.n2 VSS 3.83351f
C139 a_7700_n8758.t0 VSS 0.03569f
C140 a_7700_n8758.t1 VSS 0.03569f
C141 a_31212_n9054.t0 VSS 0.01855f
C142 a_31212_n9054.t1 VSS 0.01855f
C143 a_3336_n9278.t0 VSS 0.03804f
C144 a_3336_n9278.t1 VSS 0.03804f
C145 a_34356_n9574.t0 VSS 0.01355f
C146 a_34356_n9574.t1 VSS 0.01355f
C147 a_7700_n9798.t0 VSS 0.04143f
C148 a_7700_n9798.t1 VSS 0.04143f
C149 a_31212_n10094.t0 VSS 0.01855f
C150 a_31212_n10094.t1 VSS 0.01855f
C151 a_3336_n10318.t0 VSS 0.0377f
C152 a_3336_n10318.t1 VSS 0.0377f
C153 a_9736_n9958.t4 VSS 2.00175f
C154 a_9736_n9958.t0 VSS 0.20798f
C155 a_9736_n9958.t1 VSS 0.20798f
C156 a_9736_n9958.n0 VSS 1.36058f
C157 a_9736_n9958.n1 VSS 7.12349f
C158 a_9736_n9958.t7 VSS 0.99988f
C159 a_9736_n9958.n2 VSS 1.18741f
C160 a_9736_n9958.t6 VSS 0.99988f
C161 a_9736_n9958.n3 VSS 0.93887f
C162 a_9736_n9958.t5 VSS 1.00182f
C163 a_9736_n9958.n4 VSS 6.3496f
C164 a_9736_n9958.t2 VSS 0.20798f
C165 a_9736_n9958.t3 VSS 0.20798f
C166 a_9736_n9958.n5 VSS 2.90127f
C167 a_10256_n9958.t3 VSS 0.32973f
C168 a_10256_n9958.t1 VSS 9.41923f
C169 a_10256_n9958.n0 VSS 0.49094f
C170 a_10256_n9958.t0 VSS 9.23749f
C171 a_10256_n9958.t2 VSS 9.35052f
C172 a_10256_n9958.n1 VSS 1.10327f
C173 a_34356_n10614.t0 VSS 0.01377f
C174 a_34356_n10614.t1 VSS 0.01377f
C175 a_7700_n10838.t0 VSS 0.04528f
C176 a_7700_n10838.t1 VSS 0.04528f
C177 a_9736_n10398.t1 VSS 1.85122f
C178 a_9736_n10398.t2 VSS 2.75288f
C179 a_9736_n10398.n0 VSS 8.54117f
C180 a_9736_n10398.t0 VSS 2.35443f
C181 a_9736_n10398.n1 VSS 4.19137f
C182 a_9736_n10398.t4 VSS 1.24761f
C183 a_9736_n10398.t3 VSS 1.25185f
C184 a_9736_n10398.n2 VSS 1.67374f
C185 a_10742_n10398.t1 VSS 1.55173f
C186 a_10742_n10398.t0 VSS 14.7073f
C187 a_15736_n10918.t0 VSS 0.02783f
C188 a_15736_n10918.t1 VSS 0.02783f
C189 a_21936_n10918.t0 VSS 0.02197f
C190 a_21936_n10918.t1 VSS 0.02197f
C191 a_31212_n11134.t0 VSS 0.01855f
C192 a_31212_n11134.t1 VSS 0.01855f
C193 a_3336_n11358.t0 VSS 0.04033f
C194 a_3336_n11358.t1 VSS 0.04033f
C195 a_9736_n11358.t0 VSS 0.04829f
C196 a_9736_n11358.t1 VSS 0.04829f
C197 a_2920_n19634.t2 VSS 0.69241f
C198 a_2920_n19634.t0 VSS 1.05528f
C199 a_2920_n19634.t1 VSS 1.37896f
C200 a_2920_n19634.n0 VSS 3.45979f
C201 a_2920_n19634.t5 VSS 0.93031f
C202 a_2920_n19634.n1 VSS 2.67129f
C203 a_2920_n19634.t4 VSS 0.93032f
C204 a_2920_n19634.n2 VSS 2.74097f
C205 a_2920_n19634.t3 VSS 1.39699f
C206 a_2920_n19634.n3 VSS 4.16159f
C207 a_18870_n11438.t0 VSS 0.03292f
C208 a_18870_n11438.t1 VSS 0.03292f
C209 a_25264_n11438.t0 VSS 0.03186f
C210 a_25264_n11438.t1 VSS 0.03186f
C211 a_34356_n11654.t0 VSS 0.01355f
C212 a_34356_n11654.t1 VSS 0.01355f
C213 a_7700_n11878.t0 VSS 0.04871f
C214 a_7700_n11878.t1 VSS 0.04871f
C215 a_13712_n11878.t0 VSS 0.05307f
C216 a_13712_n11878.t1 VSS 0.05307f
C217 a_17294_n17114.t0 VSS 0.79518f
C218 a_17294_n17114.t1 VSS 0.5864f
C219 a_17294_n17114.n0 VSS 5.64094f
C220 a_17294_n17114.t3 VSS 1.51079f
C221 a_17294_n17114.t2 VSS 1.51093f
C222 a_17294_n17114.n1 VSS 1.84093f
C223 a_31212_n12174.t0 VSS 0.01855f
C224 a_31212_n12174.t1 VSS 0.01855f
C225 a_3336_n12398.t0 VSS 0.04102f
C226 a_3336_n12398.t1 VSS 0.04102f
C227 a_9736_n12398.t0 VSS 0.04561f
C228 a_9736_n12398.t1 VSS 0.04561f
C229 a_15736_n12398.t0 VSS 0.04397f
C230 a_15736_n12398.t1 VSS 0.04397f
C231 a_21936_n12398.t0 VSS 0.0462f
C232 a_21936_n12398.t1 VSS 0.0462f
C233 a_34356_n12694.t0 VSS 0.01355f
C234 a_34356_n12694.t1 VSS 0.01355f
C235 a_7700_n12918.t0 VSS 0.03947f
C236 a_7700_n12918.t1 VSS 0.03947f
C237 a_13712_n12918.t0 VSS 0.04317f
C238 a_13712_n12918.t1 VSS 0.04317f
C239 a_19136_n12918.t0 VSS 0.04496f
C240 a_19136_n12918.t1 VSS 0.04496f
C241 a_25264_n12918.t0 VSS 0.03828f
C242 a_25264_n12918.t1 VSS 0.03828f
C243 a_31212_n13214.t0 VSS 0.01855f
C244 a_31212_n13214.t1 VSS 0.01855f
C245 a_3336_n12918.t1 VSS 0.08203f
C246 a_3336_n12918.t0 VSS 0.1846f
C247 a_3336_n12918.n0 VSS 0.4597f
C248 a_3336_n12918.t5 VSS 0.1364f
C249 a_3336_n12918.n1 VSS 0.39282f
C250 a_3336_n12918.t2 VSS 0.01163f
C251 a_3336_n12918.t3 VSS 0.01163f
C252 a_3336_n12918.n2 VSS 0.13415f
C253 a_3336_n12918.n3 VSS 0.36908f
C254 a_3336_n12918.t4 VSS 35.594f
C255 a_34356_n13734.t0 VSS 0.01355f
C256 a_34356_n13734.t1 VSS 0.01355f
C257 a_31212_n14254.t0 VSS 0.01855f
C258 a_31212_n14254.t1 VSS 0.01855f
C259 a_34356_n14774.t0 VSS 0.01374f
C260 a_34356_n14774.t1 VSS 0.01374f
C261 a_31212_n15294.t0 VSS 0.01797f
C262 a_31212_n15294.t1 VSS 0.01797f
C263 a_34356_n15814.t0 VSS 0.0133f
C264 a_34356_n15814.t1 VSS 0.0133f
C265 a_2982_n17114.t0 VSS 0.59778f
C266 a_2982_n17114.t5 VSS 1.13827f
C267 a_2982_n17114.n0 VSS 1.62293f
C268 a_2982_n17114.t1 VSS 1.13204f
C269 a_2982_n17114.t2 VSS 1.31361f
C270 a_2982_n17114.n1 VSS 1.04426f
C271 a_2982_n17114.t4 VSS 1.04604f
C272 a_2982_n17114.t3 VSS 1.04609f
C273 a_2982_n17114.n2 VSS 1.15029f
C274 a_2982_n17114.n3 VSS 2.03219f
C275 a_15128_n19574.t1 VSS 1.43917f
C276 a_15128_n19574.t0 VSS 1.21736f
C277 a_15128_n19574.n0 VSS 2.78108f
C278 a_15128_n19574.t2 VSS 2.01518f
C279 a_15128_n19574.t3 VSS 1.27894f
C280 a_15128_n19574.n1 VSS 1.80535f
C281 a_9934_n17054.t0 VSS 1.02993f
C282 a_9934_n17054.t3 VSS 1.01724f
C283 a_9934_n17054.n0 VSS 0.79684f
C284 a_9934_n17054.t5 VSS 0.19587f
C285 a_9934_n17054.t4 VSS 0.19587f
C286 a_9934_n17054.n1 VSS 1.32025f
C287 a_9934_n17054.t1 VSS 1.01724f
C288 a_9934_n17054.t2 VSS 1.02993f
C289 a_9934_n17054.n2 VSS 1.06437f
C290 a_9934_n17054.n3 VSS 2.85498f
C291 a_13714_n17054.t5 VSS 0.09677f
C292 a_13714_n17054.n0 VSS 0.48121f
C293 a_13714_n17054.t2 VSS 0.90299f
C294 a_13714_n17054.t4 VSS 0.89454f
C295 a_13714_n17054.n1 VSS 0.80475f
C296 a_13714_n17054.n2 VSS 0.28848f
C297 a_13714_n17054.t1 VSS 0.09677f
C298 a_13714_n17054.t0 VSS 0.09677f
C299 a_13714_n17054.n3 VSS 1.38771f
C300 a_13714_n17054.t7 VSS 0.89657f
C301 a_13714_n17054.t6 VSS 0.90062f
C302 a_13714_n17054.n4 VSS 0.96644f
C303 a_13714_n17054.n5 VSS 3.1613f
C304 a_13714_n17054.t3 VSS 0.09677f
C305 a_31212_n16334.t0 VSS 0.01614f
C306 a_31212_n16334.t1 VSS 0.01614f
C307 a_34356_n16854.t0 VSS 0.01355f
C308 a_34356_n16854.t1 VSS 0.01355f
C309 a_31212_n17374.t0 VSS 0.01625f
C310 a_31212_n17374.t1 VSS 0.01625f
C311 a_34356_n17894.t0 VSS 0.01355f
C312 a_34356_n17894.t1 VSS 0.01355f
C313 a_31212_n18414.t0 VSS 0.01827f
C314 a_31212_n18414.t1 VSS 0.01827f
C315 a_9124_n19574.t1 VSS 0.73919f
C316 a_9124_n19574.t0 VSS 1.22035f
C317 a_9124_n19574.n0 VSS 2.5687f
C318 a_9124_n19574.t2 VSS 1.32869f
C319 VDD.n0 VSS 0.02576f
C320 VDD.t5 VSS 0.02847f
C321 VDD.t63 VSS 0.02035f
C322 VDD.t134 VSS 0.02035f
C323 VDD.t115 VSS 0.02862f
C324 VDD.n1 VSS 0.15662f
C325 VDD.t62 VSS 0.08397f
C326 VDD.t4 VSS 0.21802f
C327 VDD.n2 VSS 0.15597f
C328 VDD.t133 VSS 0.08397f
C329 VDD.t114 VSS 0.2194f
C330 VDD.n3 VSS 0.15587f
C331 VDD.n4 VSS 0.06991f
C332 VDD.n5 VSS 0.0369f
C333 VDD.n6 VSS 0.04256f
C334 VDD.n7 VSS 1.13817f
C335 VDD.t15 VSS 0.02029f
C336 VDD.n8 VSS 0.04084f
C337 VDD.t136 VSS 0.02199f
C338 VDD.t76 VSS 0.18081f
C339 VDD.t135 VSS 0.19626f
C340 VDD.t107 VSS 0.18081f
C341 VDD.t14 VSS 0.19626f
C342 VDD.n9 VSS 0.15896f
C343 VDD.n10 VSS 0.31144f
C344 VDD.n11 VSS 0.09604f
C345 VDD.n12 VSS 22.888f
C346 VDD.t3 VSS 0.03123f
C347 VDD.n13 VSS 0.09631f
C348 VDD.n14 VSS 0.10052f
C349 VDD.n15 VSS 0.10853f
C350 VDD.t120 VSS 0.11266f
C351 VDD.n16 VSS 0.1302f
C352 VDD.n17 VSS 0.08277f
C353 VDD.t2 VSS 2.32839f
C354 VDD.t105 VSS 2.60656f
C355 VDD.n18 VSS 2.5531f
C356 VDD.n19 VSS 0.15698f
C357 VDD.n20 VSS 0.11347f
C358 VDD.t106 VSS 0.11267f
C359 VDD.n21 VSS 0.13684f
C360 VDD.n22 VSS 3.8243f
C361 VDD.n23 VSS 4.02934f
C362 VDD.n24 VSS 0.02576f
C363 VDD.n25 VSS 0.03863f
C364 VDD.n26 VSS 0.03863f
C365 VDD.n27 VSS 0.13787f
C366 VDD.n28 VSS 11.6476f
C367 VDD.n29 VSS 0.07506f
C368 VDD.n30 VSS 0.42783f
C369 VDD.n31 VSS 0.60804f
C370 VDD.t125 VSS 0.44346f
C371 VDD.t64 VSS 0.48374f
C372 VDD.n32 VSS 0.84103f
C373 VDD.n33 VSS 1.15917f
C374 VDD.n34 VSS 0.03824f
C375 VDD.n35 VSS 1.15917f
C376 VDD.n36 VSS 0.04453f
C377 VDD.n37 VSS 1.15917f
C378 VDD.n38 VSS 1.15917f
C379 VDD.n39 VSS 0.03824f
C380 VDD.t113 VSS 0.2494f
C381 VDD.n40 VSS 0.14657f
C382 VDD.n41 VSS 0.10004f
C383 VDD.t10 VSS 0.24908f
C384 VDD.n42 VSS 0.14688f
C385 VDD.n43 VSS 0.10509f
C386 VDD.n44 VSS 0.03824f
C387 VDD.n45 VSS 1.15917f
C388 VDD.n46 VSS 0.73499f
C389 VDD.t40 VSS 0.45033f
C390 VDD.t26 VSS 0.42418f
C391 VDD.n47 VSS 0.70884f
C392 VDD.n48 VSS 0.03824f
C393 VDD.n49 VSS 0.64783f
C394 VDD.n50 VSS 0.03824f
C395 VDD.n51 VSS 0.07737f
C396 VDD.n52 VSS 0.03824f
C397 VDD.t6 VSS 0.36317f
C398 VDD.t41 VSS 0.51134f
C399 VDD.n53 VSS 0.796f
C400 VDD.n54 VSS 1.15917f
C401 VDD.n55 VSS 0.03824f
C402 VDD.t70 VSS 0.58107f
C403 VDD.n56 VSS 0.03824f
C404 VDD.n57 VSS 0.87299f
C405 VDD.n58 VSS 0.03824f
C406 VDD.t53 VSS 0.19244f
C407 VDD.t71 VSS 0.19053f
C408 VDD.n59 VSS 0.13977f
C409 VDD.n60 VSS 0.11364f
C410 VDD.t51 VSS 0.25033f
C411 VDD.n61 VSS 0.16429f
C412 VDD.n62 VSS 0.03824f
C413 VDD.t22 VSS 0.58107f
C414 VDD.n63 VSS 0.86428f
C415 VDD.n64 VSS 1.15917f
C416 VDD.n65 VSS 0.03824f
C417 VDD.n66 VSS 0.54896f
C418 VDD.t50 VSS 0.64926f
C419 VDD.n67 VSS 1.00083f
C420 VDD.n68 VSS 1.15917f
C421 VDD.n69 VSS 0.03824f
C422 VDD.n70 VSS 0.04453f
C423 VDD.n71 VSS 0.09386f
C424 VDD.t23 VSS 0.24963f
C425 VDD.n72 VSS 0.11543f
C426 VDD.t29 VSS 0.037f
C427 VDD.n73 VSS 0.23696f
C428 VDD.t13 VSS 0.037f
C429 VDD.n74 VSS 0.38808f
C430 VDD.n75 VSS 0.08738f
C431 VDD.n76 VSS 0.01355f
C432 VDD.n77 VSS 0.01862f
C433 VDD.t96 VSS 0.01339f
C434 VDD.t102 VSS 0.01339f
C435 VDD.n78 VSS 0.03415f
C436 VDD.t100 VSS 0.01339f
C437 VDD.t122 VSS 0.01339f
C438 VDD.n79 VSS 0.03415f
C439 VDD.n80 VSS 0.03012f
C440 VDD.n81 VSS 0.04356f
C441 VDD.n83 VSS 0.04356f
C442 VDD.n84 VSS 0.07418f
C443 VDD.n85 VSS 0.07418f
C444 VDD.n91 VSS 0.04356f
C445 VDD.n92 VSS 0.01586f
C446 VDD.t45 VSS 0.01339f
C447 VDD.t109 VSS 0.01339f
C448 VDD.n94 VSS 0.03111f
C449 VDD.n95 VSS 0.0235f
C450 VDD.n96 VSS 0.01862f
C451 VDD.n97 VSS 0.03387f
C452 VDD.n98 VSS 0.18538f
C453 VDD.t19 VSS 0.01339f
C454 VDD.t111 VSS 0.01339f
C455 VDD.n99 VSS 0.03111f
C456 VDD.n100 VSS 0.0235f
C457 VDD.n101 VSS 0.02261f
C458 VDD.t94 VSS 0.01339f
C459 VDD.t17 VSS 0.01339f
C460 VDD.n102 VSS 0.03111f
C461 VDD.n103 VSS 0.0235f
C462 VDD.n104 VSS 0.02261f
C463 VDD.t78 VSS 0.01339f
C464 VDD.t119 VSS 0.01339f
C465 VDD.n105 VSS 0.03111f
C466 VDD.n106 VSS 0.0235f
C467 VDD.n107 VSS 0.02261f
C468 VDD.t80 VSS 0.01339f
C469 VDD.t59 VSS 0.01339f
C470 VDD.n108 VSS 0.03111f
C471 VDD.n109 VSS 0.0235f
C472 VDD.n110 VSS 0.02261f
C473 VDD.t104 VSS 0.01339f
C474 VDD.t67 VSS 0.01339f
C475 VDD.n111 VSS 0.03111f
C476 VDD.n112 VSS 0.0235f
C477 VDD.n113 VSS 0.02261f
C478 VDD.n114 VSS 0.18538f
C479 VDD.n115 VSS 0.01862f
C480 VDD.t132 VSS 0.01339f
C481 VDD.t88 VSS 0.01339f
C482 VDD.n116 VSS 0.03111f
C483 VDD.n118 VSS 0.04356f
C484 VDD.n119 VSS 0.07418f
C485 VDD.n125 VSS 0.04356f
C486 VDD.n126 VSS 0.03429f
C487 VDD.t37 VSS 0.01339f
C488 VDD.t33 VSS 0.01339f
C489 VDD.n128 VSS 0.03111f
C490 VDD.n129 VSS 0.0235f
C491 VDD.n130 VSS 0.02261f
C492 VDD.n131 VSS 0.01326f
C493 VDD.t130 VSS 0.01339f
C494 VDD.t28 VSS 0.01339f
C495 VDD.n132 VSS 0.03111f
C496 VDD.n133 VSS 0.0235f
C497 VDD.n134 VSS 0.02261f
C498 VDD.n135 VSS 0.02261f
C499 VDD.t47 VSS 0.01339f
C500 VDD.t124 VSS 0.01339f
C501 VDD.n136 VSS 0.03111f
C502 VDD.n137 VSS 0.0235f
C503 VDD.t75 VSS 0.01339f
C504 VDD.t128 VSS 0.01339f
C505 VDD.n139 VSS 0.03111f
C506 VDD.n140 VSS 0.0235f
C507 VDD.n141 VSS 0.02261f
C508 VDD.t69 VSS 0.01339f
C509 VDD.t1 VSS 0.01339f
C510 VDD.n142 VSS 0.03111f
C511 VDD.n143 VSS 0.0235f
C512 VDD.n144 VSS 0.02261f
C513 VDD.t86 VSS 0.01339f
C514 VDD.t57 VSS 0.01339f
C515 VDD.n145 VSS 0.03111f
C516 VDD.n146 VSS 0.0235f
C517 VDD.n147 VSS 0.02261f
C518 VDD.t117 VSS 0.01339f
C519 VDD.t35 VSS 0.01339f
C520 VDD.n148 VSS 0.03111f
C521 VDD.n149 VSS 0.0235f
C522 VDD.n150 VSS 0.02261f
C523 VDD.t98 VSS 0.01339f
C524 VDD.t31 VSS 0.01339f
C525 VDD.n151 VSS 0.03111f
C526 VDD.n152 VSS 0.0235f
C527 VDD.n153 VSS 0.02261f
C528 VDD.t39 VSS 0.04946f
C529 VDD.n155 VSS 0.04533f
C530 VDD.n156 VSS 0.02261f
C531 VDD.n157 VSS 8.74835f
C532 VDD.n158 VSS 0.19404f
C533 VDD.n159 VSS 0.18538f
C534 VDD.n160 VSS 0.18538f
C535 VDD.n161 VSS 0.18538f
C536 VDD.n162 VSS 0.18538f
C537 VDD.n163 VSS 0.18538f
C538 VDD.n164 VSS 0.18538f
C539 VDD.n165 VSS 0.18538f
C540 VDD.n166 VSS 0.18538f
C541 VDD.n167 VSS 0.02261f
C542 VDD.t21 VSS 0.01339f
C543 VDD.t90 VSS 0.01339f
C544 VDD.n168 VSS 0.03111f
C545 VDD.n169 VSS 0.0235f
C546 VDD.t61 VSS 0.01339f
C547 VDD.t84 VSS 0.01339f
C548 VDD.n171 VSS 0.03111f
C549 VDD.n172 VSS 0.0235f
C550 VDD.n173 VSS 0.02261f
C551 VDD.n174 VSS 0.01862f
C552 VDD.n175 VSS 0.01862f
C553 VDD.n176 VSS 0.01862f
C554 VDD.n177 VSS 0.01862f
C555 VDD.n178 VSS 0.01862f
C556 VDD.n179 VSS 0.01862f
C557 VDD.n180 VSS 0.01862f
C558 VDD.n181 VSS 0.01862f
C559 VDD.n182 VSS 0.01862f
C560 VDD.n183 VSS 0.01945f
C561 VDD.n185 VSS 0.04542f
C562 VDD.n186 VSS 0.04356f
C563 VDD.n187 VSS 0.11637f
C564 VDD.n188 VSS 0.07418f
C565 VDD.n189 VSS 0.04356f
C566 VDD.n190 VSS 0.04356f
C567 VDD.n191 VSS 0.04356f
C568 VDD.n192 VSS 0.04356f
C569 VDD.n193 VSS 0.04356f
C570 VDD.n194 VSS 0.07418f
C571 VDD.n195 VSS 0.07418f
C572 VDD.n196 VSS 0.04356f
C573 VDD.n197 VSS 0.04356f
C574 VDD.n199 VSS 0.0235f
C575 VDD.n200 VSS 0.02261f
C576 VDD.n201 VSS 0.35847f
C577 VDD.t43 VSS 0.01339f
C578 VDD.t8 VSS 0.01339f
C579 VDD.n202 VSS 0.03111f
C580 VDD.n203 VSS 0.0235f
C581 VDD.n204 VSS 0.02261f
C582 VDD.n205 VSS 0.35847f
C583 VDD.n206 VSS 0.18538f
C584 VDD.n207 VSS 0.18538f
C585 VDD.n208 VSS 0.18538f
C586 VDD.n209 VSS 0.18538f
C587 VDD.n210 VSS 0.18538f
C588 VDD.n211 VSS 0.02261f
C589 VDD.t12 VSS 0.01339f
C590 VDD.t25 VSS 0.01339f
C591 VDD.n212 VSS 0.03111f
C592 VDD.n213 VSS 0.0235f
C593 VDD.n215 VSS 0.01862f
C594 VDD.n216 VSS 0.01862f
C595 VDD.n217 VSS 0.01862f
C596 VDD.n218 VSS 0.01862f
C597 VDD.n219 VSS 0.01862f
C598 VDD.n220 VSS 0.01862f
C599 VDD.n221 VSS 0.01862f
C600 VDD.t73 VSS 0.01339f
C601 VDD.t92 VSS 0.01339f
C602 VDD.n222 VSS 0.03111f
C603 VDD.n224 VSS 0.0235f
C604 VDD.n225 VSS 0.02261f
C605 VDD.n226 VSS 0.18538f
C606 VDD.t49 VSS 0.01339f
C607 VDD.t55 VSS 0.01339f
C608 VDD.n227 VSS 0.03111f
C609 VDD.n228 VSS 0.0235f
C610 VDD.n229 VSS 0.02261f
C611 VDD.n230 VSS 0.18538f
C612 VDD.t82 VSS 0.04946f
C613 VDD.n232 VSS 0.04533f
C614 VDD.n233 VSS 0.0228f
C615 VDD.n234 VSS 0.3219f
C616 VDD.n235 VSS 0.02261f
C617 VDD.n236 VSS 0.01945f
C618 VDD.n238 VSS 0.03f
C619 VDD.t18 VSS 0.12996f
C620 VDD.n239 VSS 0.03f
C621 VDD.t42 VSS 0.12996f
C622 VDD.n240 VSS 0.03f
C623 VDD.t97 VSS 0.12996f
C624 VDD.n241 VSS 0.04474f
C625 VDD.t38 VSS 0.3997f
C626 VDD.t36 VSS 0.17473f
C627 VDD.t32 VSS 0.17473f
C628 VDD.t129 VSS 0.12996f
C629 VDD.n242 VSS 0.08524f
C630 VDD.t27 VSS 0.13214f
C631 VDD.t46 VSS 0.17473f
C632 VDD.t123 VSS 0.17473f
C633 VDD.t74 VSS 0.12996f
C634 VDD.n243 VSS 0.0844f
C635 VDD.t127 VSS 0.13214f
C636 VDD.t68 VSS 0.17473f
C637 VDD.t0 VSS 0.17473f
C638 VDD.t85 VSS 0.12996f
C639 VDD.t34 VSS 0.17473f
C640 VDD.t116 VSS 0.17473f
C641 VDD.t56 VSS 0.13214f
C642 VDD.n244 VSS 0.0844f
C643 VDD.n245 VSS 0.03f
C644 VDD.n246 VSS 0.03f
C645 VDD.n247 VSS 0.0844f
C646 VDD.t30 VSS 0.13214f
C647 VDD.t20 VSS 0.17473f
C648 VDD.t89 VSS 0.17473f
C649 VDD.t60 VSS 0.12996f
C650 VDD.n248 VSS 0.0844f
C651 VDD.t83 VSS 0.13214f
C652 VDD.t131 VSS 0.17473f
C653 VDD.t87 VSS 0.17473f
C654 VDD.t99 VSS 0.12996f
C655 VDD.t101 VSS 0.17473f
C656 VDD.t95 VSS 0.17473f
C657 VDD.t121 VSS 0.13214f
C658 VDD.n249 VSS 0.0844f
C659 VDD.n250 VSS 0.03f
C660 VDD.n251 VSS 0.03f
C661 VDD.n252 VSS 0.0844f
C662 VDD.t7 VSS 0.13214f
C663 VDD.t11 VSS 0.17473f
C664 VDD.t24 VSS 0.17473f
C665 VDD.t103 VSS 0.12996f
C666 VDD.n253 VSS 0.0844f
C667 VDD.t66 VSS 0.13214f
C668 VDD.t79 VSS 0.17473f
C669 VDD.t58 VSS 0.17473f
C670 VDD.t77 VSS 0.12996f
C671 VDD.t16 VSS 0.17473f
C672 VDD.t93 VSS 0.17473f
C673 VDD.t118 VSS 0.13214f
C674 VDD.n254 VSS 0.0844f
C675 VDD.n255 VSS 0.03f
C676 VDD.n256 VSS 0.03f
C677 VDD.n257 VSS 0.0844f
C678 VDD.t110 VSS 0.13214f
C679 VDD.t72 VSS 0.17473f
C680 VDD.t91 VSS 0.17473f
C681 VDD.t48 VSS 0.12996f
C682 VDD.n258 VSS 0.0844f
C683 VDD.t54 VSS 0.13214f
C684 VDD.t44 VSS 0.17473f
C685 VDD.t108 VSS 0.17473f
C686 VDD.t81 VSS 0.18733f
C687 VDD.n259 VSS 0.22782f
C688 VDD.n260 VSS 0.02323f
C689 VDD.n261 VSS 0.04345f
C690 VDD.n262 VSS 0.04356f
C691 VDD.n263 VSS 0.11637f
C692 VDD.n264 VSS 0.07418f
C693 VDD.n265 VSS 0.04356f
C694 VDD.n266 VSS 0.04356f
C695 VDD.n267 VSS 0.04356f
C696 VDD.n268 VSS 0.04356f
C697 VDD.n269 VSS 0.04356f
C698 VDD.n270 VSS 0.07418f
C699 VDD.n271 VSS 0.07418f
C700 VDD.n272 VSS 0.04356f
C701 VDD.n273 VSS 0.04356f
C702 VDD.n274 VSS 0.03012f
C703 VDD.n275 VSS 0.01118f
C704 VDD.n276 VSS 0.37285f
C705 VDD.n277 VSS 0.39552f
C706 VDD.n278 VSS 0.08974f
C707 VDD.n279 VSS 0.04453f
C708 VDD.n280 VSS 1.15917f
C709 VDD.n281 VSS 1.15917f
C710 VDD.n282 VSS 0.99211f
C711 VDD.n283 VSS 0.03824f
C712 VDD.n284 VSS 0.04453f
C713 VDD.n285 VSS 0.21784f
C714 VDD.t52 VSS 0.58107f
C715 VDD.n286 VSS 1.10542f
C716 VDD.n287 VSS 1.15917f
C717 VDD.n288 VSS 0.03824f
C718 VDD.n289 VSS 0.04453f
C719 VDD.n290 VSS 0.13198f
C720 VDD.n291 VSS 0.12168f
C721 VDD.n292 VSS 0.04453f
C722 VDD.n293 VSS 1.15917f
C723 VDD.n294 VSS 1.15917f
C724 VDD.n295 VSS 1.15917f
C725 VDD.n296 VSS 0.03824f
C726 VDD.n297 VSS 0.04453f
C727 VDD.n298 VSS 0.08047f
C728 VDD.n299 VSS 0.09721f
C729 VDD.n300 VSS 0.04453f
C730 VDD.n301 VSS 0.03824f
C731 VDD.n302 VSS 0.03824f
C732 VDD.n303 VSS 0.58536f
C733 VDD.t9 VSS 0.58107f
C734 VDD.n304 VSS 1.1519f
C735 VDD.n305 VSS 1.15917f
C736 VDD.n306 VSS 0.03824f
C737 VDD.n307 VSS 0.03824f
C738 VDD.n308 VSS 0.04453f
C739 VDD.n309 VSS 0.7132f
C740 VDD.t112 VSS 0.58107f
C741 VDD.n310 VSS 1.02407f
C742 VDD.n311 VSS 1.15917f
C743 VDD.n312 VSS 0.03824f
C744 VDD.n313 VSS 0.04042f
C745 VDD.n314 VSS 0.25687f
C746 VDD.n315 VSS 0.0886f
C747 VDD.t126 VSS 0.14064f
C748 VDD.t65 VSS 0.13774f
C749 VDD.n316 VSS 0.13735f
C750 VDD.n317 VSS 0.20471f
C751 VCTRL.t4 VSS 2.16958f
C752 VCTRL.t5 VSS 1.97922f
C753 VCTRL.n0 VSS 3.44368f
C754 VCTRL.t1 VSS 0.01225f
C755 VCTRL.n1 VSS 0.19806f
C756 VCTRL.n2 VSS 0.76488f
C757 VCTRL.t0 VSS 0.01365f
C758 VCTRL.n3 VSS 0.32913f
C759 VCTRL.t3 VSS 0.12299f
C760 FB_1M.t0 VSS 0.10128f
C761 FB_1M.t1 VSS 0.04808f
C762 FB_1M.t2 VSS 0.06088f
C763 FB_1M.n0 VSS 0.42644f
C764 FB_1M.n1 VSS 0.92289f
C765 UPB.t4 VSS 0.03171f
C766 UPB.t3 VSS 0.01838f
C767 UPB.n0 VSS 0.12974f
C768 UPB.t1 VSS 0.05813f
C769 UPB.t0 VSS 0.03019f
C770 UPB.n1 VSS 0.15436f
C771 UPB.t2 VSS 0.02832f
C772 UPB.n2 VSS 0.06047f
C773 UPB.n3 VSS 0.08383f
C774 UPB.t5 VSS 0.3565f
C775 REF_1M.t2 VSS 0.05936f
C776 REF_1M.t1 VSS 0.16835f
C777 REF_1M.t0 VSS 0.03715f
C778 REF_1M.n0 VSS 0.88868f
C779 DN.t2 VSS 0.0457f
C780 DN.t0 VSS 0.03355f
C781 DN.t1 VSS 0.01627f
C782 DN.n0 VSS 0.07959f
C783 DN.t3 VSS 0.01419f
C784 DN.n1 VSS 0.1463f
C785 CP_IBIAS.t0 VSS 0.46855f
C786 CP_IBIAS.t3 VSS 0.12872f
C787 CP_IBIAS.n0 VSS 0.16319f
C788 CP_IBIAS.t1 VSS 0.12498f
C789 CP_IBIAS.t4 VSS 0.12619f
C790 CP_IBIAS.n1 VSS 0.17368f
C791 CP_IBIAS.t2 VSS 0.02703f
C792 CP_IBIAS.n2 VSS 0.05284f
C793 CP_IBIAS.n3 VSS 0.038f
C794 CP_IBIAS.n4 VSS 0.26611f
C795 TAIL_BIAS.t2 VSS 0.04329f
C796 TAIL_BIAS.t3 VSS 0.82151f
C797 TAIL_BIAS.t4 VSS 0.75145f
C798 TAIL_BIAS.n0 VSS 1.04785f
C799 TAIL_BIAS.t5 VSS 0.82125f
C800 TAIL_BIAS.n1 VSS 0.50791f
C801 TAIL_BIAS.n2 VSS 0.08419f
C802 TAIL_BIAS.t1 VSS 0.01265f
C803 TAIL_BIAS.n3 VSS 0.0446f
C804 TAIL_BIAS.t0 VSS 0.06462f
C805 TAIL_BIAS.n4 VSS 0.03753f
C806 VDD_VCO.n0 VSS 0.07654f
C807 VDD_VCO.t41 VSS 0.01106f
C808 VDD_VCO.t24 VSS 0.01106f
C809 VDD_VCO.n1 VSS 0.04455f
C810 VDD_VCO.n2 VSS 0.02092f
C811 VDD_VCO.t33 VSS 0.01106f
C812 VDD_VCO.t17 VSS 0.01106f
C813 VDD_VCO.n3 VSS 0.04455f
C814 VDD_VCO.n4 VSS 0.07824f
C815 VDD_VCO.t22 VSS 0.01106f
C816 VDD_VCO.t27 VSS 0.01106f
C817 VDD_VCO.n5 VSS 0.04455f
C818 VDD_VCO.n6 VSS 0.02092f
C819 VDD_VCO.t20 VSS 0.01106f
C820 VDD_VCO.t26 VSS 0.01106f
C821 VDD_VCO.n7 VSS 0.04455f
C822 VDD_VCO.n8 VSS 0.07824f
C823 VDD_VCO.t44 VSS 0.01106f
C824 VDD_VCO.t35 VSS 0.01106f
C825 VDD_VCO.n9 VSS 0.04455f
C826 VDD_VCO.n10 VSS 0.02092f
C827 VDD_VCO.t38 VSS 0.01106f
C828 VDD_VCO.t14 VSS 0.01106f
C829 VDD_VCO.n11 VSS 0.04455f
C830 VDD_VCO.n12 VSS 0.07824f
C831 VDD_VCO.t9 VSS 0.01106f
C832 VDD_VCO.t5 VSS 0.01106f
C833 VDD_VCO.n13 VSS 0.04455f
C834 VDD_VCO.n14 VSS 0.02092f
C835 VDD_VCO.t32 VSS 0.01106f
C836 VDD_VCO.t21 VSS 0.01106f
C837 VDD_VCO.n15 VSS 0.04455f
C838 VDD_VCO.n16 VSS 0.07824f
C839 VDD_VCO.t46 VSS 0.01106f
C840 VDD_VCO.t23 VSS 0.01106f
C841 VDD_VCO.n17 VSS 0.04455f
C842 VDD_VCO.n18 VSS 0.02092f
C843 VDD_VCO.t0 VSS 0.01106f
C844 VDD_VCO.t30 VSS 0.01106f
C845 VDD_VCO.n19 VSS 0.04455f
C846 VDD_VCO.n20 VSS 0.21855f
C847 VDD_VCO.t10 VSS 0.01106f
C848 VDD_VCO.t47 VSS 0.01106f
C849 VDD_VCO.n21 VSS 0.04455f
C850 VDD_VCO.t13 VSS 0.01106f
C851 VDD_VCO.t12 VSS 0.01106f
C852 VDD_VCO.n22 VSS 0.04557f
C853 VDD_VCO.n23 VSS 0.03348f
C854 VDD_VCO.n24 VSS 0.02092f
C855 VDD_VCO.t7 VSS 0.01106f
C856 VDD_VCO.t16 VSS 0.01106f
C857 VDD_VCO.n25 VSS 0.04455f
C858 VDD_VCO.n26 VSS 0.02092f
C859 VDD_VCO.t45 VSS 0.01106f
C860 VDD_VCO.t25 VSS 0.01106f
C861 VDD_VCO.n27 VSS 0.04455f
C862 VDD_VCO.n28 VSS 0.02092f
C863 VDD_VCO.n29 VSS 0.07824f
C864 VDD_VCO.n30 VSS 0.07824f
C865 VDD_VCO.n31 VSS 0.07824f
C866 VDD_VCO.n32 VSS 0.02092f
C867 VDD_VCO.t19 VSS 0.01106f
C868 VDD_VCO.t42 VSS 0.01106f
C869 VDD_VCO.n33 VSS 0.04455f
C870 VDD_VCO.n34 VSS 0.02092f
C871 VDD_VCO.t11 VSS 0.01106f
C872 VDD_VCO.t36 VSS 0.01106f
C873 VDD_VCO.n35 VSS 0.04455f
C874 VDD_VCO.n36 VSS 0.02092f
C875 VDD_VCO.n37 VSS 0.07824f
C876 VDD_VCO.n38 VSS 0.07824f
C877 VDD_VCO.n39 VSS 0.07824f
C878 VDD_VCO.n40 VSS 0.02092f
C879 VDD_VCO.t29 VSS 0.01106f
C880 VDD_VCO.t48 VSS 0.01106f
C881 VDD_VCO.n41 VSS 0.04455f
C882 VDD_VCO.n42 VSS 0.02092f
C883 VDD_VCO.t31 VSS 0.01106f
C884 VDD_VCO.t37 VSS 0.01106f
C885 VDD_VCO.n43 VSS 0.04455f
C886 VDD_VCO.n44 VSS 0.02092f
C887 VDD_VCO.n45 VSS 0.07824f
C888 VDD_VCO.n46 VSS 0.07824f
C889 VDD_VCO.n47 VSS 0.07824f
C890 VDD_VCO.n48 VSS 0.02092f
C891 VDD_VCO.t1 VSS 0.01106f
C892 VDD_VCO.t2 VSS 0.01106f
C893 VDD_VCO.n49 VSS 0.04455f
C894 VDD_VCO.n50 VSS 0.02092f
C895 VDD_VCO.t6 VSS 0.01106f
C896 VDD_VCO.t39 VSS 0.01106f
C897 VDD_VCO.n51 VSS 0.04455f
C898 VDD_VCO.n52 VSS 0.02092f
C899 VDD_VCO.n53 VSS 0.07824f
C900 VDD_VCO.n54 VSS 0.07824f
C901 VDD_VCO.n55 VSS 0.07824f
C902 VDD_VCO.n56 VSS 0.02092f
C903 VDD_VCO.t43 VSS 0.01106f
C904 VDD_VCO.t34 VSS 0.01106f
C905 VDD_VCO.n57 VSS 0.04455f
C906 VDD_VCO.n58 VSS 0.02092f
C907 VDD_VCO.t3 VSS 0.01106f
C908 VDD_VCO.t4 VSS 0.01106f
C909 VDD_VCO.n59 VSS 0.04455f
C910 VDD_VCO.n60 VSS 0.02092f
C911 VDD_VCO.n61 VSS 0.07824f
C912 VDD_VCO.n62 VSS 0.07824f
C913 VDD_VCO.n63 VSS 0.07824f
C914 VDD_VCO.n64 VSS 0.02092f
C915 VDD_VCO.t18 VSS 0.01106f
C916 VDD_VCO.t15 VSS 0.01106f
C917 VDD_VCO.n65 VSS 0.04455f
C918 VDD_VCO.t8 VSS 0.15959f
C919 VDD_VCO.t49 VSS 1.89033f
C920 VDD_VCO.t50 VSS 1.75393f
C921 VDD_VCO.n66 VSS 1.547f
C922 VDD_VCO.t51 VSS 1.75393f
C923 VDD_VCO.n67 VSS 0.85608f
C924 VDD_VCO.t52 VSS 1.75393f
C925 VDD_VCO.n68 VSS 0.85608f
C926 VDD_VCO.t53 VSS 1.75393f
C927 VDD_VCO.n69 VSS 0.85608f
C928 VDD_VCO.t54 VSS 1.75393f
C929 VDD_VCO.n70 VSS 0.85608f
C930 VDD_VCO.t55 VSS 1.75393f
C931 VDD_VCO.n71 VSS 0.85608f
C932 VDD_VCO.t56 VSS 1.75393f
C933 VDD_VCO.n72 VSS 0.85608f
C934 VDD_VCO.t57 VSS 1.75393f
C935 VDD_VCO.n73 VSS 0.84013f
C936 VDD_VCO.t66 VSS 1.89033f
C937 VDD_VCO.t65 VSS 1.75393f
C938 VDD_VCO.n74 VSS 1.547f
C939 VDD_VCO.t64 VSS 1.75393f
C940 VDD_VCO.n75 VSS 0.85608f
C941 VDD_VCO.t63 VSS 1.75393f
C942 VDD_VCO.n76 VSS 0.85608f
C943 VDD_VCO.t62 VSS 1.75393f
C944 VDD_VCO.n77 VSS 0.85608f
C945 VDD_VCO.t61 VSS 1.75393f
C946 VDD_VCO.n78 VSS 0.85608f
C947 VDD_VCO.t60 VSS 1.75393f
C948 VDD_VCO.n79 VSS 0.85608f
C949 VDD_VCO.t59 VSS 1.75393f
C950 VDD_VCO.n80 VSS 0.85608f
C951 VDD_VCO.t58 VSS 1.75393f
C952 VDD_VCO.n81 VSS 0.84158f
C953 VDD_VCO.n82 VSS 0.05256f
C954 VDD_VCO.n83 VSS 0.85279f
C955 VDD_VCO.n84 VSS 0.36684f
C956 VDD_VCO.n85 VSS 0.01752f
C957 VDD_VCO.t40 VSS 0.01106f
C958 VDD_VCO.t28 VSS 0.01106f
C959 VDD_VCO.n86 VSS 0.04455f
C960 VDD_VCO.n87 VSS 0.01582f
C961 VDD_VCO.n88 VSS 0.29224f
.ends
