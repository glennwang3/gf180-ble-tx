* NGSPICE file created from TS_PFD_FLAT.ext - technology: gf180mcuE

.subckt TS_PFD_FLAT R V UPB DN 3v3 vss UP
X0 vss.t74 a_6196_n3250.t4 a_9220_n3184.t3 vss.t72 nfet_03v3 ad=0.3416p pd=2.34u as=0.3416p ps=2.34u w=0.56u l=0.28u
X1 a_142_344.t1 a_6244_n236.t3 vss.t54 vss.t53 nfet_03v3 ad=0.3416p pd=2.34u as=0.3416p ps=2.34u w=0.56u l=0.28u
X2 a_808_64.t2 a_672_184.t5 vss.t66 vss.t26 nfet_03v3 ad=0.3416p pd=2.34u as=0.3416p ps=2.34u w=0.56u l=0.28u
X3 a_10128_n86.t2 a_672_184.t2 vss.t47 vss.t19 nfet_03v3 ad=0.3416p pd=2.34u as=0.3416p ps=2.34u w=0.56u l=0.28u
X4 3v3.t42 a_3846_158.t4 a_672_184.t0 3v3.t41 pfet_03v3 ad=0.728p pd=3.54u as=0.728p ps=3.54u w=1.12u l=0.28u
X5 a_8144_n3014.t0 a_672_n3060.t3 3v3.t37 3v3.t36 pfet_03v3 ad=0.728p pd=3.54u as=0.728p ps=3.54u w=1.12u l=0.28u
X6 a_8144_84.t1 a_672_184.t4 vss.t59 vss.t58 nfet_03v3 ad=0.3416p pd=2.34u as=0.3416p ps=2.34u w=0.56u l=0.28u
X7 a_6244_n236.t0 UP.t6 vss.t10 vss.t9 nfet_03v3 ad=0.3416p pd=2.34u as=0.3416p ps=2.34u w=0.56u l=0.28u
X8 a_6332_n3184.t1 a_6196_n3250.t3 3v3.t58 3v3.t57 pfet_03v3 ad=0.2912p pd=1.64u as=0.728p ps=3.54u w=1.12u l=0.28u
X9 a_808_n2994.t0 a_672_n3060.t4 a_808_n3154.t0 3v3.t15 pfet_03v3 ad=0.728p pd=3.54u as=0.2912p ps=1.64u w=1.12u l=0.28u
X10 3v3.t70 a_2278_n16.t3 a_3846_158.t2 3v3.t59 pfet_03v3 ad=0.728p pd=3.54u as=0.728p ps=3.54u w=1.12u l=0.28u
X11 vss.t49 a_3326_n3030.t3 a_4132_n2572.t1 vss.t48 nfet_03v3 ad=0.3416p pd=2.34u as=0.1456p ps=1.08u w=0.56u l=0.28u
X12 vss.t43 V.t6 a_1776_n2478.t1 vss.t0 nfet_03v3 ad=0.3416p pd=2.34u as=0.1456p ps=1.08u w=0.56u l=0.28u
X13 3v3.t64 a_672_184.t6 a_8144_84.t0 3v3.t63 pfet_03v3 ad=0.728p pd=3.54u as=0.728p ps=3.54u w=1.12u l=0.28u
X14 a_9220_n3184.t1 a_8144_n3014.t2 3v3.t66 3v3.t65 pfet_03v3 ad=0.728p pd=3.54u as=0.728p ps=3.54u w=1.12u l=0.28u
X15 vss.t27 a_672_n3060.t8 a_808_n2994.t1 vss.t26 nfet_03v3 ad=0.3416p pd=2.34u as=0.3416p ps=2.34u w=0.56u l=0.28u
X16 vss.t52 a_142_n3220.t5 a_278_n2994.t1 vss.t51 nfet_03v3 ad=0.3416p pd=2.34u as=0.3416p ps=2.34u w=0.56u l=0.28u
X17 vss.t70 a_10128_n2836.t4 DN.t0 vss.t40 nfet_03v3 ad=0.3416p pd=2.34u as=0.3416p ps=2.34u w=0.56u l=0.28u
X18 a_10128_n86.t0 R.t1 a_10128_n246.t0 vss.t4 nfet_03v3 ad=0.3416p pd=2.34u as=0.1456p ps=1.08u w=0.56u l=0.28u
X19 a_8686_442.t0 3v3.t19 a_8686_282.t1 3v3.t20 pfet_03v3 ad=0.2912p pd=1.64u as=0.2912p ps=1.64u w=1.12u l=0.28u
X20 a_1726_n2994.t1 a_808_n2994.t3 3v3.t83 3v3.t82 pfet_03v3 ad=0.728p pd=3.54u as=0.728p ps=3.54u w=1.12u l=0.28u
X21 a_14186_n1300.t1 UP.t3 vss.t12 vss.t11 nfet_03v3 ad=0.3416p pd=2.34u as=0.3416p ps=2.34u w=0.56u l=0.28u
X22 a_848_n426.t0 R.t3 vss.t3 vss.t2 nfet_03v3 ad=0.1456p pd=1.08u as=0.3416p ps=2.34u w=0.56u l=0.28u
X23 vss.t35 a_672_n3060.t7 a_8144_n3014.t1 vss.t34 nfet_03v3 ad=0.3416p pd=2.34u as=0.3416p ps=2.34u w=0.56u l=0.28u
X24 a_3846_n3088.t0 a_3326_n3030.t2 3v3.t31 3v3.t30 pfet_03v3 ad=0.728p pd=3.54u as=0.728p ps=3.54u w=1.12u l=0.28u
X25 a_278_250.t0 R.t6 a_278_64.t0 3v3.t4 pfet_03v3 ad=0.2912p pd=1.64u as=0.728p ps=3.54u w=1.12u l=0.28u
X26 a_808_250.t1 a_672_184.t7 a_808_64.t0 3v3.t4 pfet_03v3 ad=0.2912p pd=1.64u as=0.728p ps=3.54u w=1.12u l=0.28u
X27 vss.t42 V.t7 a_848_n2478.t0 vss.t2 nfet_03v3 ad=0.3416p pd=2.34u as=0.1456p ps=1.08u w=0.56u l=0.28u
X28 vss.t71 a_9220_n3184.t5 a_10128_n2658.t1 vss.t4 nfet_03v3 ad=0.3416p pd=2.34u as=0.1456p ps=1.08u w=0.56u l=0.28u
X29 a_10128_n2836.t2 a_9220_n3184.t4 3v3.t81 3v3.t80 pfet_03v3 ad=0.728p pd=3.54u as=0.728p ps=3.54u w=1.12u l=0.28u
X30 UP.t0 a_10128_n86.t3 vss.t41 vss.t40 nfet_03v3 ad=0.3416p pd=2.34u as=0.3416p ps=2.34u w=0.56u l=0.28u
X31 a_8686_n3186.t0 3v3.t24 a_8686_n3346.t0 3v3.t25 pfet_03v3 ad=0.2912p pd=1.64u as=0.2912p ps=1.64u w=1.12u l=0.28u
X32 3v3.t12 UP.t4 a_14186_n1300.t0 3v3.t11 pfet_03v3 ad=0.728p pd=3.54u as=0.728p ps=3.54u w=1.12u l=0.28u
X33 a_8686_282.t0 R.t4 a_8566_n246.t0 3v3.t7 pfet_03v3 ad=0.2912p pd=1.64u as=0.728p ps=3.54u w=1.12u l=0.28u
X34 a_4132_n332.t0 a_3326_100.t2 vss.t18 vss.t17 nfet_03v3 ad=0.1456p pd=1.08u as=0.3416p ps=2.34u w=0.56u l=0.28u
X35 a_3326_100.t0 a_142_344.t2 vss.t56 vss.t55 nfet_03v3 ad=0.3416p pd=2.34u as=0.3416p ps=2.34u w=0.56u l=0.28u
X36 a_808_64.t1 a_278_64.t2 a_848_n426.t1 vss.t2 nfet_03v3 ad=0.3416p pd=2.34u as=0.1456p ps=1.08u w=0.56u l=0.28u
X37 vss.t24 3v3.t86 a_8566_n2676.t0 vss.t21 nfet_03v3 ad=0.3416p pd=2.34u as=0.3416p ps=2.34u w=0.56u l=0.28u
X38 a_6244_n236.t2 a_6196_n3250.t7 vss.t25 vss.t9 nfet_03v3 ad=0.3416p pd=2.34u as=0.3416p ps=2.34u w=0.56u l=0.28u
X39 a_6196_n3250.t1 a_12036_n1242.t3 vss.t68 vss.t67 nfet_03v3 ad=0.3416p pd=2.34u as=0.3416p ps=2.34u w=0.56u l=0.28u
X40 a_278_64.t1 a_142_344.t3 vss.t69 vss.t51 nfet_03v3 ad=0.3416p pd=2.34u as=0.3416p ps=2.34u w=0.56u l=0.28u
X41 vss.t46 a_6196_n3250.t5 a_6244_n2686.t2 vss.t37 nfet_03v3 ad=0.3416p pd=2.34u as=0.3416p ps=2.34u w=0.56u l=0.28u
X42 vss.t39 a_1726_n2994.t3 a_2278_n2914.t0 vss.t13 nfet_03v3 ad=0.3416p pd=2.34u as=0.3416p ps=2.34u w=0.56u l=0.28u
X43 a_14992_n1732.t1 a_14186_n1300.t2 vss.t65 vss.t23 nfet_03v3 ad=0.1456p pd=1.08u as=0.3416p ps=2.34u w=0.56u l=0.28u
X44 a_2278_n16.t1 a_1726_64.t2 vss.t14 vss.t13 nfet_03v3 ad=0.3416p pd=2.34u as=0.3416p ps=2.34u w=0.56u l=0.28u
X45 UPB.t0 a_14706_n1242.t3 vss.t29 vss.t28 nfet_03v3 ad=0.3416p pd=2.34u as=0.3416p ps=2.34u w=0.56u l=0.28u
X46 a_2278_n2914.t1 a_1726_n2994.t2 3v3.t47 3v3.t46 pfet_03v3 ad=0.728p pd=3.54u as=0.728p ps=3.54u w=1.12u l=0.28u
X47 3v3.t17 a_9220_254.t5 a_10128_n86.t1 3v3.t16 pfet_03v3 ad=0.728p pd=3.54u as=0.728p ps=3.54u w=1.12u l=0.28u
X48 vss.t38 DN.t3 a_6244_n2686.t1 vss.t37 nfet_03v3 ad=0.3416p pd=2.34u as=0.3416p ps=2.34u w=0.56u l=0.28u
X49 3v3.t72 a_6196_n3250.t9 a_6332_280.t1 3v3.t71 pfet_03v3 ad=0.728p pd=3.54u as=0.2912p ps=1.64u w=1.12u l=0.28u
X50 a_6244_n2686.t0 DN.t2 a_6332_n3184.t0 3v3.t40 pfet_03v3 ad=0.728p pd=3.54u as=0.2912p ps=1.64u w=1.12u l=0.28u
X51 vss.t20 a_672_n3060.t5 a_10128_n2836.t0 vss.t19 nfet_03v3 ad=0.3416p pd=2.34u as=0.3416p ps=2.34u w=0.56u l=0.28u
X52 3v3.t10 UP.t5 a_12036_n1242.t0 3v3.t9 pfet_03v3 ad=0.728p pd=3.54u as=0.728p ps=3.54u w=1.12u l=0.28u
X53 a_3846_158.t1 a_2278_n16.t2 a_4132_n332.t1 vss.t57 nfet_03v3 ad=0.3416p pd=2.34u as=0.1456p ps=1.08u w=0.56u l=0.28u
X54 a_9328_n2658.t1 a_8566_n2676.t3 a_9220_n3184.t2 vss.t5 nfet_03v3 ad=0.1456p pd=1.08u as=0.3416p ps=2.34u w=0.56u l=0.28u
X55 a_8566_n246.t1 3v3.t88 vss.t22 vss.t21 nfet_03v3 ad=0.3416p pd=2.34u as=0.3416p ps=2.34u w=0.56u l=0.28u
X56 3v3.t1 a_6244_n236.t4 a_142_344.t0 3v3.t0 pfet_03v3 ad=0.728p pd=3.54u as=0.728p ps=3.54u w=1.12u l=0.28u
X57 3v3.t14 a_1726_64.t3 a_2278_n16.t0 3v3.t13 pfet_03v3 ad=0.728p pd=3.54u as=0.728p ps=3.54u w=1.12u l=0.28u
X58 a_278_n3154.t1 a_142_n3220.t2 3v3.t75 3v3.t52 pfet_03v3 ad=0.2912p pd=1.64u as=0.728p ps=3.54u w=1.12u l=0.28u
X59 a_14706_n1242.t1 3v3.t87 a_14992_n1732.t0 vss.t23 nfet_03v3 ad=0.3416p pd=2.34u as=0.1456p ps=1.08u w=0.56u l=0.28u
X60 3v3.t6 R.t5 a_9220_440.t0 3v3.t5 pfet_03v3 ad=0.728p pd=3.54u as=0.2912p ps=1.64u w=1.12u l=0.28u
X61 3v3.t69 a_14186_n1300.t3 a_14706_n1242.t2 3v3.t22 pfet_03v3 ad=0.728p pd=3.54u as=0.728p ps=3.54u w=1.12u l=0.28u
X62 a_9328_n246.t0 R.t0 vss.t6 vss.t5 nfet_03v3 ad=0.1456p pd=1.08u as=0.3416p ps=2.34u w=0.56u l=0.28u
X63 a_8566_n246.t2 a_672_184.t3 vss.t60 vss.t30 nfet_03v3 ad=0.3416p pd=2.34u as=0.3416p ps=2.34u w=0.56u l=0.28u
X64 a_1776_n426.t0 R.t2 vss.t1 vss.t0 nfet_03v3 ad=0.1456p pd=1.08u as=0.3416p ps=2.34u w=0.56u l=0.28u
X65 a_6332_280.t0 UP.t7 a_6244_n236.t1 3v3.t8 pfet_03v3 ad=0.2912p pd=1.64u as=0.728p ps=3.54u w=1.12u l=0.28u
X66 3v3.t23 3v3.t21 a_14706_n1242.t0 3v3.t22 pfet_03v3 ad=0.728p pd=3.54u as=0.728p ps=3.54u w=1.12u l=0.28u
X67 a_3846_n3088.t1 a_2278_n2914.t2 3v3.t45 3v3.t44 pfet_03v3 ad=0.728p pd=3.54u as=0.728p ps=3.54u w=1.12u l=0.28u
X68 3v3.t85 a_142_344.t4 a_3326_100.t1 3v3.t84 pfet_03v3 ad=0.728p pd=3.54u as=0.728p ps=3.54u w=1.12u l=0.28u
X69 a_672_n3060.t0 a_3846_n3088.t3 3v3.t33 3v3.t32 pfet_03v3 ad=0.728p pd=3.54u as=0.728p ps=3.54u w=1.12u l=0.28u
X70 a_12322_n1732.t0 UP.t2 vss.t8 vss.t7 nfet_03v3 ad=0.1456p pd=1.08u as=0.3416p ps=2.34u w=0.56u l=0.28u
X71 3v3.t39 DN.t5 a_12036_n1242.t1 3v3.t38 pfet_03v3 ad=0.728p pd=3.54u as=0.728p ps=3.54u w=1.12u l=0.28u
X72 a_808_n3154.t1 V.t2 3v3.t53 3v3.t15 pfet_03v3 ad=0.2912p pd=1.64u as=0.728p ps=3.54u w=1.12u l=0.28u
X73 vss.t62 a_6244_n2686.t4 a_142_n3220.t1 vss.t61 nfet_03v3 ad=0.3416p pd=2.34u as=0.3416p ps=2.34u w=0.56u l=0.28u
X74 a_1776_n2478.t0 a_808_n2994.t4 a_1726_n2994.t0 vss.t0 nfet_03v3 ad=0.1456p pd=1.08u as=0.3416p ps=2.34u w=0.56u l=0.28u
X75 3v3.t62 a_8144_84.t2 a_9220_254.t2 3v3.t61 pfet_03v3 ad=0.728p pd=3.54u as=0.728p ps=3.54u w=1.12u l=0.28u
X76 a_4132_n2572.t0 a_2278_n2914.t3 a_3846_n3088.t2 vss.t45 nfet_03v3 ad=0.1456p pd=1.08u as=0.3416p ps=2.34u w=0.56u l=0.28u
X77 a_8566_n2676.t2 V.t1 a_8686_n3186.t1 3v3.t54 pfet_03v3 ad=0.728p pd=3.54u as=0.2912p ps=1.64u w=1.12u l=0.28u
X78 a_1726_64.t1 a_808_64.t3 a_1776_n426.t1 vss.t0 nfet_03v3 ad=0.3416p pd=2.34u as=0.1456p ps=1.08u w=0.56u l=0.28u
X79 3v3.t77 a_12036_n1242.t4 a_6196_n3250.t0 3v3.t76 pfet_03v3 ad=0.728p pd=3.54u as=0.728p ps=3.54u w=1.12u l=0.28u
X80 3v3.t26 a_808_64.t4 a_1726_64.t0 3v3.t4 pfet_03v3 ad=0.728p pd=3.54u as=0.728p ps=3.54u w=1.12u l=0.28u
X81 vss.t64 a_142_n3220.t4 a_3326_n3030.t0 vss.t63 nfet_03v3 ad=0.3416p pd=2.34u as=0.3416p ps=2.34u w=0.56u l=0.28u
X82 vss.t33 a_3846_n3088.t4 a_672_n3060.t1 vss.t32 nfet_03v3 ad=0.3416p pd=2.34u as=0.3416p ps=2.34u w=0.56u l=0.28u
X83 3v3.t51 a_672_184.t8 a_8686_442.t1 3v3.t50 pfet_03v3 ad=0.728p pd=3.54u as=0.2912p ps=1.64u w=1.12u l=0.28u
X84 DN.t1 a_10128_n2836.t3 3v3.t79 3v3.t78 pfet_03v3 ad=0.728p pd=3.54u as=0.728p ps=3.54u w=1.12u l=0.28u
X85 3v3.t35 a_14706_n1242.t4 UPB.t1 3v3.t34 pfet_03v3 ad=0.728p pd=3.54u as=0.728p ps=3.54u w=1.12u l=0.28u
X86 a_10128_n246.t1 a_9220_254.t4 vss.t50 vss.t4 nfet_03v3 ad=0.1456p pd=1.08u as=0.3416p ps=2.34u w=0.56u l=0.28u
X87 a_9220_n3344.t1 V.t0 3v3.t56 3v3.t55 pfet_03v3 ad=0.2912p pd=1.64u as=0.728p ps=3.54u w=1.12u l=0.28u
X88 3v3.t60 a_3326_100.t3 a_3846_158.t0 3v3.t59 pfet_03v3 ad=0.728p pd=3.54u as=0.728p ps=3.54u w=1.12u l=0.28u
X89 a_12036_n1242.t2 DN.t4 a_12322_n1732.t1 vss.t36 nfet_03v3 ad=0.3416p pd=2.34u as=0.1456p ps=1.08u w=0.56u l=0.28u
X90 3v3.t43 a_142_344.t5 a_278_250.t1 3v3.t2 pfet_03v3 ad=0.728p pd=3.54u as=0.2912p ps=1.64u w=1.12u l=0.28u
X91 3v3.t3 R.t7 a_808_250.t0 3v3.t2 pfet_03v3 ad=0.728p pd=3.54u as=0.2912p ps=1.64u w=1.12u l=0.28u
X92 a_848_n2478.t1 a_278_n2994.t2 a_808_n2994.t2 vss.t2 nfet_03v3 ad=0.1456p pd=1.08u as=0.3416p ps=2.34u w=0.56u l=0.28u
X93 a_142_n3220.t0 a_6244_n2686.t3 3v3.t68 3v3.t67 pfet_03v3 ad=0.728p pd=3.54u as=0.728p ps=3.54u w=1.12u l=0.28u
X94 a_10128_n2658.t0 V.t4 a_10128_n2836.t1 vss.t4 nfet_03v3 ad=0.1456p pd=1.08u as=0.3416p ps=2.34u w=0.56u l=0.28u
X95 a_9220_254.t3 a_6196_n3250.t6 vss.t73 vss.t72 nfet_03v3 ad=0.3416p pd=2.34u as=0.3416p ps=2.34u w=0.56u l=0.28u
X96 vss.t44 V.t5 a_9328_n2658.t0 vss.t5 nfet_03v3 ad=0.3416p pd=2.34u as=0.1456p ps=1.08u w=0.56u l=0.28u
X97 a_3326_n3030.t1 a_142_n3220.t3 3v3.t74 3v3.t73 pfet_03v3 ad=0.728p pd=3.54u as=0.728p ps=3.54u w=1.12u l=0.28u
X98 a_672_184.t1 a_3846_158.t3 vss.t16 vss.t15 nfet_03v3 ad=0.3416p pd=2.34u as=0.3416p ps=2.34u w=0.56u l=0.28u
X99 a_278_n2994.t0 V.t3 a_278_n3154.t0 3v3.t52 pfet_03v3 ad=0.728p pd=3.54u as=0.2912p ps=1.64u w=1.12u l=0.28u
X100 a_9220_440.t1 a_6196_n3250.t8 a_9220_254.t0 3v3.t18 pfet_03v3 ad=0.2912p pd=1.64u as=0.728p ps=3.54u w=1.12u l=0.28u
X101 vss.t31 a_672_n3060.t6 a_8566_n2676.t1 vss.t30 nfet_03v3 ad=0.3416p pd=2.34u as=0.3416p ps=2.34u w=0.56u l=0.28u
X102 a_8686_n3346.t1 a_672_n3060.t2 3v3.t29 3v3.t28 pfet_03v3 ad=0.2912p pd=1.64u as=0.728p ps=3.54u w=1.12u l=0.28u
X103 a_9220_n3184.t0 a_6196_n3250.t2 a_9220_n3344.t0 3v3.t27 pfet_03v3 ad=0.728p pd=3.54u as=0.2912p ps=1.64u w=1.12u l=0.28u
X104 a_9220_254.t1 a_8566_n246.t3 a_9328_n246.t1 vss.t5 nfet_03v3 ad=0.3416p pd=2.34u as=0.1456p ps=1.08u w=0.56u l=0.28u
X105 3v3.t49 a_10128_n86.t4 UP.t1 3v3.t48 pfet_03v3 ad=0.728p pd=3.54u as=0.728p ps=3.54u w=1.12u l=0.28u
R0 V.n3 V.t3 39.3434
R1 V.n0 V.t0 39.2373
R2 V.n0 V.t1 39.1473
R3 V.n3 V.t2 38.8259
R4 V.n4 V.t6 32.7248
R5 V.n4 V.t7 31.2719
R6 V.n2 V.t4 31.2719
R7 V.n1 V.t5 31.2719
R8 V.n5 V.n2 20.0545
R9 V.n5 V.n4 18.8735
R10 V V.n5 14.6866
R11 V.n4 V.n3 1.5755
R12 V.n2 V.n1 1.41479
R13 V.n1 V.n0 1.18014
R14 UPB UPB.n0 30.6404
R15 UPB.n0 UPB.t0 11.3343
R16 UPB.n0 UPB.t1 5.2255
R17 DN.n0 DN.t5 40.2691
R18 DN.n3 DN.t2 34.743
R19 DN.n0 DN.t4 31.2719
R20 DN.n3 DN.t3 26.9734
R21 DN.n4 DN.n3 23.702
R22 DN.n2 DN.n1 22.5061
R23 DN.n2 DN.n0 19.0005
R24 DN.n1 DN.t0 11.3343
R25 DN DN.n4 6.40788
R26 DN.n1 DN.t1 5.2255
R27 DN.n4 DN.n2 1.29179
R28 UP.n4 UP.t7 34.743
R29 UP.n2 UP.t5 34.6863
R30 UP.n1 UP.t4 34.5141
R31 UP.n2 UP.t2 27.8734
R32 UP.n1 UP.t3 27.2141
R33 UP.n4 UP.t6 26.9734
R34 UP.n5 UP.n4 24.5452
R35 UP.n3 UP.n1 23.1514
R36 UP.n3 UP.n2 22.949
R37 UP UP.n0 18.0005
R38 UP.n0 UP.t0 11.3343
R39 UP.n0 UP.t1 5.2255
R40 UP UP.n5 4.52862
R41 UP.n5 UP.n3 0.448
R42 R.n3 R.t6 39.3434
R43 R.n0 R.t5 39.2373
R44 R.n0 R.t4 39.1473
R45 R.n3 R.t7 38.8259
R46 R.n4 R.t2 32.7248
R47 R.n4 R.t3 31.2719
R48 R.n2 R.t1 31.2719
R49 R.n1 R.t0 31.2719
R50 R.n5 R.n2 20.3996
R51 R.n5 R.n4 18.056
R52 R R.n5 5.74163
R53 R.n4 R.n3 1.5755
R54 R.n2 R.n1 1.41479
R55 R.n1 R.n0 1.18014
R56 3v3.t44 3v3.t32 890.909
R57 3v3.t80 3v3.t78 846.735
R58 3v3.t16 3v3.t48 846.735
R59 3v3.n47 3v3.t76 793.939
R60 3v3.t30 3v3.t73 787.88
R61 3v3.t38 3v3.t9 696.971
R62 3v3.t82 3v3.t46 661.87
R63 3v3.n3 3v3.n2 649.429
R64 3v3.n13 3v3.n12 649.429
R65 3v3.t15 3v3.t52 635.492
R66 3v3.n29 3v3.t15 563.549
R67 3v3.n29 3v3.t82 537.17
R68 3v3.n24 3v3.t30 400
R69 3v3.n2 3v3.t80 391.961
R70 3v3.n12 3v3.t16 391.961
R71 3v3.n1 3v3.t65 318.183
R72 3v3.n11 3v3.t61 318.183
R73 3v3.n38 3v3.t71 315.171
R74 3v3.n55 3v3.t57 315.171
R75 3v3.t55 3v3.t27 299.625
R76 3v3.t5 3v3.t18 299.625
R77 3v3.n24 3v3.t44 296.971
R78 3v3.t25 3v3.t54 169.851
R79 3v3.t20 3v3.t7 169.851
R80 3v3.n0 3v3.t25 168.791
R81 3v3.n10 3v3.t20 168.791
R82 3v3.n44 3v3.t22 168.346
R83 3v3.n35 3v3.t59 168.346
R84 3v3.n21 3v3.t2 143.858
R85 3v3.n47 3v3.t38 96.9702
R86 3v3.t71 3v3.t0 82.7073
R87 3v3.t57 3v3.t67 82.7073
R88 3v3.t0 3v3.t8 67.6697
R89 3v3.t67 3v3.t40 67.6697
R90 3v3.t2 3v3.t4 66.6672
R91 3v3.n42 3v3.t21 40.2691
R92 3v3.n9 3v3.t19 39.803
R93 3v3.n53 3v3.t24 39.803
R94 3v3.t4 3v3.t13 33.3338
R95 3v3.n9 3v3.t88 31.2719
R96 3v3.n42 3v3.t87 31.2719
R97 3v3.n53 3v3.t86 31.2719
R98 3v3.t22 3v3.t11 29.472
R99 3v3.t59 3v3.t84 29.472
R100 3v3.n50 3v3.n49 22.79
R101 3v3.n32 3v3.n26 19.04
R102 3v3.n58 3v3.n8 18.7604
R103 3v3.n57 3v3.n56 18.6152
R104 3v3.n41 3v3.n18 18.3904
R105 3v3.n33 3v3.n22 18.047
R106 3v3.n40 3v3.n39 18.0087
R107 3v3.n46 3v3.n45 18.0035
R108 3v3.n37 3v3.n36 18.0035
R109 3v3.n32 3v3.n31 18.0005
R110 3v3.n46 3v3.n42 14.156
R111 3v3.n54 3v3.n53 13.989
R112 3v3.n52 3v3.n9 13.5378
R113 3v3.n1 3v3.n0 13.1091
R114 3v3.n11 3v3.n10 13.1091
R115 3v3.t54 3v3.t36 12.7394
R116 3v3.t7 3v3.t63 12.7394
R117 3v3.n33 3v3.n32 11.0298
R118 3v3.t11 3v3.t34 9.14684
R119 3v3.t84 3v3.t41 9.14684
R120 3v3.n7 3v3.t37 6.66124
R121 3v3.n17 3v3.t64 6.66124
R122 3v3.n4 3v3.t79 6.37762
R123 3v3.n14 3v3.t49 6.37762
R124 3v3.n19 3v3.t14 5.95915
R125 3v3.n27 3v3.t47 5.95915
R126 3v3.n48 3v3.t77 5.9168
R127 3v3.n43 3v3.t35 5.9168
R128 3v3.n34 3v3.t42 5.9168
R129 3v3.n23 3v3.t33 5.9168
R130 3v3.n45 3v3.t12 5.8177
R131 3v3.n36 3v3.t85 5.8177
R132 3v3.n26 3v3.t74 5.8177
R133 3v3.n20 3v3.t43 5.80869
R134 3v3.n28 3v3.t75 5.80869
R135 3v3.n38 3v3.t1 5.70386
R136 3v3.n55 3v3.t68 5.70386
R137 3v3.n19 3v3.t26 5.4237
R138 3v3.n27 3v3.t83 5.4237
R139 3v3.n20 3v3.t3 5.3428
R140 3v3.n28 3v3.t53 5.3428
R141 3v3.n39 3v3.t72 5.33775
R142 3v3.n56 3v3.t58 5.33775
R143 3v3.n51 3v3.n50 5.33762
R144 3v3.n49 3v3.t10 5.33572
R145 3v3.n48 3v3.t39 5.33572
R146 3v3.n45 3v3.t69 5.33572
R147 3v3.n43 3v3.t23 5.33572
R148 3v3.n36 3v3.t60 5.33572
R149 3v3.n34 3v3.t70 5.33572
R150 3v3.n26 3v3.t31 5.33572
R151 3v3.n23 3v3.t45 5.33572
R152 3v3.n6 3v3.t56 5.22651
R153 3v3.n16 3v3.t6 5.22651
R154 3v3.n7 3v3.t29 5.2255
R155 3v3.n5 3v3.t66 5.2255
R156 3v3.n4 3v3.t81 5.2255
R157 3v3.n17 3v3.t51 5.2255
R158 3v3.n15 3v3.t62 5.2255
R159 3v3.n14 3v3.t17 5.2255
R160 3v3.n50 3v3.n46 5.04005
R161 3v3.n2 3v3.n1 4.13273
R162 3v3.n12 3v3.n11 4.13273
R163 3v3.n0 3v3.t55 1.87316
R164 3v3.n10 3v3.t5 1.87316
R165 3v3.n40 3v3.n37 1.14496
R166 3v3.n54 3v3.n52 1.06313
R167 3v3.n0 3v3.t28 1.06207
R168 3v3.n10 3v3.t50 1.06207
R169 3v3.n37 3v3.n33 0.99288
R170 3v3.n6 3v3.n5 0.943544
R171 3v3.n16 3v3.n15 0.943544
R172 3v3.n48 3v3.n47 0.9005
R173 3v3.n41 3v3.n40 0.892546
R174 3v3.n5 3v3.n4 0.864768
R175 3v3.n15 3v3.n14 0.864768
R176 3v3.n7 3v3.n6 0.697022
R177 3v3.n17 3v3.n16 0.697022
R178 3v3.n52 3v3.n51 0.6695
R179 3v3.n25 3v3.n24 0.663658
R180 3v3 3v3.n58 0.64175
R181 3v3.n30 3v3.n29 0.5255
R182 3v3.n21 3v3.n20 0.504765
R183 3v3.n30 3v3.n28 0.504765
R184 3v3.n8 3v3.n3 0.471676
R185 3v3.n18 3v3.n13 0.471676
R186 3v3.n22 3v3.n21 0.389618
R187 3v3.n31 3v3.n30 0.389618
R188 3v3.n49 3v3.n48 0.373735
R189 3v3.n39 3v3.n38 0.322118
R190 3v3.n56 3v3.n55 0.322118
R191 3v3.n57 3v3.n54 0.248
R192 3v3.n45 3v3.n44 0.232118
R193 3v3.n36 3v3.n35 0.232118
R194 3v3.n26 3v3.n25 0.232118
R195 3v3.n44 3v3.n43 0.142118
R196 3v3.n35 3v3.n34 0.142118
R197 3v3.n25 3v3.n23 0.142118
R198 3v3.n6 3v3.n3 0.10668
R199 3v3.n8 3v3.n7 0.10668
R200 3v3.n16 3v3.n13 0.10668
R201 3v3.n18 3v3.n17 0.10668
R202 3v3.n58 3v3.n57 0.07925
R203 3v3.n22 3v3.n19 0.0706471
R204 3v3.n31 3v3.n27 0.0706471
R205 3v3.n51 3v3.n41 0.017
R206 vss.t45 vss.n61 153571
R207 vss.n19 vss.n7 147941
R208 vss.t57 vss.n43 146677
R209 vss.n60 vss.n43 73402.8
R210 vss.n61 vss.n60 59715.1
R211 vss.n42 vss.n7 49727.4
R212 vss.n20 vss.n6 14462.9
R213 vss.n43 vss.n42 13908.1
R214 vss.n6 vss.t61 12005.6
R215 vss.n2 vss.t58 9148.75
R216 vss.n2 vss.t34 9148.75
R217 vss.n21 vss.n20 8342.83
R218 vss.n21 vss.n7 7340.82
R219 vss.n61 vss.n6 6860.29
R220 vss.n20 vss.n12 3891.94
R221 vss.n41 vss.n2 953.333
R222 vss.n5 vss.n2 953.333
R223 vss.n12 vss.t7 930.345
R224 vss.t67 vss.t11 919.749
R225 vss.n46 vss.n2 919.343
R226 vss.n62 vss.n2 919.343
R227 vss.t2 vss.t51 641.976
R228 vss.t0 vss.t13 631.944
R229 vss.n18 vss.t28 627.633
R230 vss.t26 vss.t0 579.283
R231 vss.t5 vss.t30 509.928
R232 vss.t7 vss.t36 496.183
R233 vss.t19 vss.t40 486.654
R234 vss.n19 vss.t23 431.498
R235 vss.t72 vss.t4 399.902
R236 vss.n46 vss.t17 372.707
R237 vss.n62 vss.t48 372.707
R238 vss.t9 vss.n41 342.106
R239 vss.t37 vss.n5 342.106
R240 vss.t30 vss.t21 332.387
R241 vss.t4 vss.t19 321.615
R242 vss.t13 vss.n2 318.481
R243 vss.t40 vss.n21 268.717
R244 vss.n30 vss.t72 252.849
R245 vss.n60 vss.n59 244.502
R246 vss.n20 vss.t67 239.698
R247 vss.t11 vss.n19 239.536
R248 vss.n60 vss.t2 234.471
R249 vss.n42 vss.t53 225.79
R250 vss.n30 vss.t5 193.605
R251 vss.t21 vss.n2 191.584
R252 vss.n59 vss.t26 105.325
R253 vss.t17 vss.t15 104.359
R254 vss.t48 vss.t32 104.359
R255 vss.t53 vss.t9 82.1058
R256 vss.t61 vss.t37 82.1058
R257 vss.t55 vss.t57 72.0571
R258 vss.t63 vss.t45 72.0571
R259 vss.n38 vss.n37 22.6768
R260 vss.t15 vss.t55 22.3629
R261 vss.t32 vss.t63 22.3629
R262 vss.n16 vss.n15 19.2094
R263 vss.n54 vss.n53 18.8679
R264 vss.n66 vss.n0 18.5022
R265 vss.n53 vss.n52 18.1764
R266 vss.n49 vss.n48 18.0039
R267 vss.n22 vss.n8 18.001
R268 vss.n36 vss.n35 18.001
R269 vss.n15 vss.n14 18.0005
R270 vss.n65 vss.n64 18.0005
R271 vss.n37 vss.n36 15.1143
R272 vss.n17 vss.t12 12.1122
R273 vss.n47 vss.t56 12.1122
R274 vss.n63 vss.t64 12.1122
R275 vss.n44 vss.t69 11.8252
R276 vss.n57 vss.t52 11.8252
R277 vss.n40 vss.t54 11.5367
R278 vss.n4 vss.t62 11.5367
R279 vss.n13 vss.t8 11.3376
R280 vss.n14 vss.t68 11.2927
R281 vss.n48 vss.t16 11.2927
R282 vss.n64 vss.t33 11.2927
R283 vss.n16 vss.t29 11.2927
R284 vss.n50 vss.t66 11.2481
R285 vss.n56 vss.t27 11.2481
R286 vss.n52 vss.t14 11.1534
R287 vss.n54 vss.t39 11.1534
R288 vss.n44 vss.t3 11.0587
R289 vss.n51 vss.t1 11.0587
R290 vss.n57 vss.t42 11.0587
R291 vss.n55 vss.t43 11.0587
R292 vss.n39 vss.t25 11.0279
R293 vss.n38 vss.t10 11.0279
R294 vss.n47 vss.t18 11.0279
R295 vss.n63 vss.t49 11.0279
R296 vss.n17 vss.t65 11.0279
R297 vss.n3 vss.t46 11.0279
R298 vss.n0 vss.t38 11.0279
R299 vss.n22 vss.t70 10.9981
R300 vss.n35 vss.t41 10.9981
R301 vss.n9 vss.t59 10.9511
R302 vss.n26 vss.t35 10.9511
R303 vss.n25 vss.t74 10.9366
R304 vss.n32 vss.t73 10.9366
R305 vss.n23 vss.t20 10.8556
R306 vss.n34 vss.t47 10.8556
R307 vss.n9 vss.t22 10.8005
R308 vss.n10 vss.t60 10.8005
R309 vss.n11 vss.t6 10.8005
R310 vss.n33 vss.t50 10.8005
R311 vss.n26 vss.t24 10.8005
R312 vss.n27 vss.t31 10.8005
R313 vss.n28 vss.t44 10.8005
R314 vss.n24 vss.t71 10.8005
R315 vss.t23 vss.n18 10.0159
R316 vss.n37 vss.n1 4.9895
R317 vss vss.n66 1.35243
R318 vss.n15 vss.n8 1.17268
R319 vss.n53 vss.n49 1.055
R320 vss.n36 vss.n8 0.9317
R321 vss.n41 vss.n40 0.867167
R322 vss.n5 vss.n4 0.867167
R323 vss.n48 vss.n47 0.721703
R324 vss.n64 vss.n63 0.721703
R325 vss.n17 vss.n16 0.721703
R326 vss.n13 vss.n12 0.693833
R327 vss.n65 vss.n1 0.635855
R328 vss.n52 vss.n51 0.566971
R329 vss.n55 vss.n54 0.566971
R330 vss.n18 vss.n17 0.5205
R331 vss.n63 vss.n62 0.5205
R332 vss.n47 vss.n46 0.5205
R333 vss.n51 vss.n50 0.511382
R334 vss.n56 vss.n55 0.511382
R335 vss.n45 vss.n44 0.455794
R336 vss.n58 vss.n57 0.455794
R337 vss.n14 vss.n13 0.411997
R338 vss.n59 vss.n45 0.4005
R339 vss.n59 vss.n58 0.4005
R340 vss.n66 vss.n65 0.362759
R341 vss.n30 vss.n29 0.359121
R342 vss.n31 vss.n30 0.359121
R343 vss.n39 vss.n38 0.291676
R344 vss.n3 vss.n0 0.291676
R345 vss.n28 vss.n27 0.17046
R346 vss.n11 vss.n10 0.17046
R347 vss.n23 vss.n22 0.163191
R348 vss.n35 vss.n34 0.163191
R349 vss.n25 vss.n24 0.136038
R350 vss.n33 vss.n32 0.136038
R351 vss.n24 vss.n23 0.109391
R352 vss.n34 vss.n33 0.109391
R353 vss.n27 vss.n26 0.103767
R354 vss.n10 vss.n9 0.103767
R355 vss.n29 vss.n25 0.0861972
R356 vss.n32 vss.n31 0.0861972
R357 vss.n49 vss.n1 0.085943
R358 vss.n40 vss.n39 0.0825588
R359 vss.n4 vss.n3 0.0825588
R360 vss.n29 vss.n28 0.0661175
R361 vss.n31 vss.n11 0.0661175
R362 vss.n50 vss.n45 0.0613824
R363 vss.n58 vss.n56 0.0613824
R364 a_9220_n3344.t0 a_9220_n3344.t1 3.2505
R365 a_8686_n3346.t0 a_8686_n3346.t1 3.2505
R366 a_8686_n3186.t0 a_8686_n3186.t1 3.2505
R367 a_6332_n3184.t0 a_6332_n3184.t1 3.2505
R368 a_808_n3154.t0 a_808_n3154.t1 3.2505
R369 a_278_n3154.t0 a_278_n3154.t1 3.2505
R370 a_10128_n2836.t0 a_10128_n2836.n2 11.1331
R371 a_10128_n2836.n2 a_10128_n2836.n1 0.313543
R372 a_10128_n2836.n2 a_10128_n2836.n0 0.603109
R373 a_10128_n2836.n1 a_10128_n2836.t2 5.52058
R374 a_10128_n2836.n1 a_10128_n2836.t1 11.2505
R375 a_10128_n2836.n0 a_10128_n2836.t4 27.1867
R376 a_10128_n2836.n0 a_10128_n2836.t3 34.518
R377 a_10128_n2658.t0 a_10128_n2658.t1 5.8505
R378 a_9328_n2658.t0 a_9328_n2658.t1 5.8505
R379 a_9220_n3184.t2 a_9220_n3184.n0 11.004
R380 a_9220_n3184.n0 a_9220_n3184.n1 0.743978
R381 a_9220_n3184.n1 a_9220_n3184.t1 5.48537
R382 a_9220_n3184.n1 a_9220_n3184.t3 11.047
R383 a_9220_n3184.n1 a_9220_n3184.n2 5.2205
R384 a_9220_n3184.n2 a_9220_n3184.t5 32.1944
R385 a_9220_n3184.n2 a_9220_n3184.t4 39.1698
R386 a_9220_n3184.n0 a_9220_n3184.t0 5.4886
R387 a_8566_n2676.t0 a_8566_n2676.n1 11.0588
R388 a_8566_n2676.n1 a_8566_n2676.n0 0.282239
R389 a_8566_n2676.n0 a_8566_n2676.t3 27.8734
R390 a_8566_n2676.n0 a_8566_n2676.t2 5.35624
R391 a_8566_n2676.n1 a_8566_n2676.t1 11.047
R392 a_8144_n3014.t1 a_8144_n3014.n0 10.9962
R393 a_8144_n3014.n0 a_8144_n3014.t0 5.50271
R394 a_8144_n3014.n0 a_8144_n3014.t2 63.1127
R395 a_6244_n2686.t1 a_6244_n2686.n2 11.0725
R396 a_6244_n2686.n2 a_6244_n2686.n0 0.223543
R397 a_6244_n2686.n0 a_6244_n2686.n1 0.877022
R398 a_6244_n2686.n1 a_6244_n2686.t4 27.0811
R399 a_6244_n2686.n1 a_6244_n2686.t3 34.6237
R400 a_6244_n2686.n0 a_6244_n2686.t0 5.39145
R401 a_6244_n2686.n2 a_6244_n2686.t2 11.049
R402 a_3846_n3088.t2 a_3846_n3088.n2 11.0196
R403 a_3846_n3088.n2 a_3846_n3088.n1 0.4505
R404 a_3846_n3088.n1 a_3846_n3088.n0 0.747891
R405 a_3846_n3088.n1 a_3846_n3088.t1 5.41102
R406 a_3846_n3088.n2 a_3846_n3088.t0 5.86102
R407 a_3846_n3088.n0 a_3846_n3088.t4 27.3511
R408 a_3846_n3088.n0 a_3846_n3088.t3 34.3537
R409 a_4132_n2572.t0 a_4132_n2572.t1 5.8505
R410 a_3326_n3030.t0 a_3326_n3030.n0 11.0157
R411 a_3326_n3030.n0 a_3326_n3030.n1 0.712674
R412 a_3326_n3030.n1 a_3326_n3030.t3 27.9165
R413 a_3326_n3030.n1 a_3326_n3030.t2 34.6198
R414 a_3326_n3030.n0 a_3326_n3030.t1 5.45967
R415 a_2278_n2914.t0 a_2278_n2914.n0 11.3343
R416 a_2278_n2914.n0 a_2278_n2914.n1 33.0887
R417 a_2278_n2914.n1 a_2278_n2914.t2 40.2691
R418 a_2278_n2914.n1 a_2278_n2914.t3 31.2719
R419 a_2278_n2914.n0 a_2278_n2914.t1 5.2255
R420 a_1726_n2994.t0 a_1726_n2994.n0 10.9766
R421 a_1726_n2994.n0 a_1726_n2994.n1 0.689196
R422 a_1726_n2994.n1 a_1726_n2994.t3 27.3158
R423 a_1726_n2994.n1 a_1726_n2994.t2 34.3889
R424 a_1726_n2994.n0 a_1726_n2994.t1 5.45406
R425 a_1776_n2478.t0 a_1776_n2478.t1 5.8505
R426 a_808_n2994.t1 a_808_n2994.n2 10.9883
R427 a_808_n2994.n2 a_808_n2994.n0 0.912239
R428 a_808_n2994.n2 a_808_n2994.n1 0.21963
R429 a_808_n2994.n1 a_808_n2994.t3 34.7743
R430 a_808_n2994.n0 a_808_n2994.t2 10.9883
R431 a_808_n2994.n0 a_808_n2994.t0 5.44232
R432 a_808_n2994.n1 a_808_n2994.t4 27.5584
R433 a_672_n3060.t1 a_672_n3060.n0 11.3343
R434 a_672_n3060.n0 a_672_n3060.n6 22.5192
R435 a_672_n3060.n6 a_672_n3060.n5 14.5485
R436 a_672_n3060.n5 a_672_n3060.t4 44.6341
R437 a_672_n3060.n5 a_672_n3060.t8 35.7719
R438 a_672_n3060.n6 a_672_n3060.n4 23.2547
R439 a_672_n3060.n4 a_672_n3060.n1 0.458326
R440 a_672_n3060.n1 a_672_n3060.n2 10.3216
R441 a_672_n3060.n2 a_672_n3060.n3 1.47264
R442 a_672_n3060.n3 a_672_n3060.t5 38.668
R443 a_672_n3060.n3 a_672_n3060.t6 36.2833
R444 a_672_n3060.n2 a_672_n3060.t2 43.0719
R445 a_672_n3060.n1 a_672_n3060.t3 34.0719
R446 a_672_n3060.n4 a_672_n3060.t7 27.1945
R447 a_672_n3060.n0 a_672_n3060.t0 5.2255
R448 a_848_n2478.t0 a_848_n2478.t1 5.8505
R449 a_278_n2994.t1 a_278_n2994.n0 10.9962
R450 a_278_n2994.n0 a_278_n2994.t2 27.8832
R451 a_278_n2994.n0 a_278_n2994.t0 5.4345
R452 a_142_n3220.t1 a_142_n3220.n0 11.3343
R453 a_142_n3220.n0 a_142_n3220.n2 24.7047
R454 a_142_n3220.n2 a_142_n3220.n3 24.4779
R455 a_142_n3220.n3 a_142_n3220.t2 34.8761
R456 a_142_n3220.n3 a_142_n3220.t5 27.6934
R457 a_142_n3220.n2 a_142_n3220.n1 23.187
R458 a_142_n3220.n1 a_142_n3220.t3 34.5141
R459 a_142_n3220.n1 a_142_n3220.t4 27.2141
R460 a_142_n3220.n0 a_142_n3220.t0 5.2255
R461 a_14992_n1732.t0 a_14992_n1732.t1 5.8505
R462 a_12322_n1732.t0 a_12322_n1732.t1 5.8505
R463 a_14706_n1242.t1 a_14706_n1242.n2 11.0196
R464 a_14706_n1242.n2 a_14706_n1242.n1 0.4505
R465 a_14706_n1242.n1 a_14706_n1242.n0 0.747891
R466 a_14706_n1242.n2 a_14706_n1242.t2 5.86102
R467 a_14706_n1242.n1 a_14706_n1242.t0 5.41102
R468 a_14706_n1242.n0 a_14706_n1242.t4 34.3537
R469 a_14706_n1242.n0 a_14706_n1242.t3 27.3511
R470 a_14186_n1300.t1 a_14186_n1300.n0 11.0157
R471 a_14186_n1300.n0 a_14186_n1300.n1 0.712674
R472 a_14186_n1300.n1 a_14186_n1300.t3 34.6198
R473 a_14186_n1300.n1 a_14186_n1300.t2 27.9165
R474 a_14186_n1300.n0 a_14186_n1300.t0 5.45967
R475 a_12036_n1242.t2 a_12036_n1242.n2 11.0196
R476 a_12036_n1242.n2 a_12036_n1242.n1 0.4505
R477 a_12036_n1242.n1 a_12036_n1242.n0 0.747891
R478 a_12036_n1242.n2 a_12036_n1242.t0 5.86102
R479 a_12036_n1242.n1 a_12036_n1242.t1 5.41102
R480 a_12036_n1242.n0 a_12036_n1242.t4 34.3537
R481 a_12036_n1242.n0 a_12036_n1242.t3 27.3511
R482 a_10128_n246.t0 a_10128_n246.t1 5.8505
R483 a_9328_n246.t0 a_9328_n246.t1 5.8505
R484 a_4132_n332.t0 a_4132_n332.t1 5.8505
R485 a_1776_n426.t0 a_1776_n426.t1 5.8505
R486 a_848_n426.t0 a_848_n426.t1 5.8505
R487 a_8566_n246.t1 a_8566_n246.n1 11.0588
R488 a_8566_n246.n1 a_8566_n246.n0 0.282239
R489 a_8566_n246.n0 a_8566_n246.t3 27.8734
R490 a_8566_n246.n0 a_8566_n246.t0 5.35624
R491 a_8566_n246.n1 a_8566_n246.t2 11.047
R492 a_10128_n86.t0 a_10128_n86.n1 11.2505
R493 a_10128_n86.n1 a_10128_n86.n2 0.313543
R494 a_10128_n86.n2 a_10128_n86.n0 0.603109
R495 a_10128_n86.n2 a_10128_n86.t2 11.1331
R496 a_10128_n86.n1 a_10128_n86.t1 5.52058
R497 a_10128_n86.n0 a_10128_n86.t4 34.518
R498 a_10128_n86.n0 a_10128_n86.t3 27.1867
R499 a_8686_282.t0 a_8686_282.t1 3.2505
R500 a_9220_254.t1 a_9220_254.n0 11.004
R501 a_9220_254.n0 a_9220_254.n1 0.743978
R502 a_9220_254.n1 a_9220_254.t3 11.047
R503 a_9220_254.n1 a_9220_254.t2 5.48537
R504 a_9220_254.n1 a_9220_254.n2 5.2205
R505 a_9220_254.n2 a_9220_254.t5 39.1698
R506 a_9220_254.n2 a_9220_254.t4 32.1944
R507 a_9220_254.n0 a_9220_254.t0 5.4886
R508 a_8144_84.t1 a_8144_84.n0 10.9962
R509 a_8144_84.n0 a_8144_84.t0 5.50271
R510 a_8144_84.n0 a_8144_84.t2 63.1127
R511 a_9220_440.t0 a_9220_440.t1 3.2505
R512 a_8686_442.t0 a_8686_442.t1 3.2505
R513 a_6244_n236.t0 a_6244_n236.n2 11.0725
R514 a_6244_n236.n2 a_6244_n236.n0 0.223543
R515 a_6244_n236.n0 a_6244_n236.n1 0.877022
R516 a_6244_n236.n1 a_6244_n236.t4 34.6237
R517 a_6244_n236.n1 a_6244_n236.t3 27.0811
R518 a_6244_n236.n0 a_6244_n236.t1 5.39145
R519 a_6244_n236.n2 a_6244_n236.t2 11.049
R520 a_6332_280.t0 a_6332_280.t1 3.2505
R521 a_3846_158.t1 a_3846_158.n2 11.0196
R522 a_3846_158.n2 a_3846_158.n1 0.4505
R523 a_3846_158.n1 a_3846_158.n0 0.747891
R524 a_3846_158.n2 a_3846_158.t0 5.86102
R525 a_3846_158.n1 a_3846_158.t2 5.41102
R526 a_3846_158.n0 a_3846_158.t4 34.3537
R527 a_3846_158.n0 a_3846_158.t3 27.3511
R528 a_2278_n16.t1 a_2278_n16.n0 11.3343
R529 a_2278_n16.n0 a_2278_n16.n1 32.8925
R530 a_2278_n16.n1 a_2278_n16.t3 40.2691
R531 a_2278_n16.n1 a_2278_n16.t2 31.2719
R532 a_2278_n16.n0 a_2278_n16.t0 5.2255
R533 a_6196_n3250.t1 a_6196_n3250.n0 11.3343
R534 a_6196_n3250.n0 a_6196_n3250.n7 23.3671
R535 a_6196_n3250.n7 a_6196_n3250.n2 0.148
R536 a_6196_n3250.n2 a_6196_n3250.n6 0.7505
R537 a_6196_n3250.n6 a_6196_n3250.n5 18.7957
R538 a_6196_n3250.n5 a_6196_n3250.t3 40.4009
R539 a_6196_n3250.n5 a_6196_n3250.t5 31.2719
R540 a_6196_n3250.n6 a_6196_n3250.n4 18.1857
R541 a_6196_n3250.n4 a_6196_n3250.t9 40.4009
R542 a_6196_n3250.n4 a_6196_n3250.t7 31.2719
R543 a_6196_n3250.n2 a_6196_n3250.n3 18.2897
R544 a_6196_n3250.n3 a_6196_n3250.t8 40.1694
R545 a_6196_n3250.n3 a_6196_n3250.t6 31.2719
R546 a_6196_n3250.n7 a_6196_n3250.n1 18.5622
R547 a_6196_n3250.n1 a_6196_n3250.t2 40.1694
R548 a_6196_n3250.n1 a_6196_n3250.t4 31.2719
R549 a_6196_n3250.n0 a_6196_n3250.t0 5.2255
R550 a_3326_100.t0 a_3326_100.n0 11.0157
R551 a_3326_100.n0 a_3326_100.n1 0.712674
R552 a_3326_100.n1 a_3326_100.t3 34.6198
R553 a_3326_100.n1 a_3326_100.t2 27.9165
R554 a_3326_100.n0 a_3326_100.t1 5.45967
R555 a_1726_64.t1 a_1726_64.n0 10.9766
R556 a_1726_64.n0 a_1726_64.n1 0.689196
R557 a_1726_64.n1 a_1726_64.t3 34.3889
R558 a_1726_64.n1 a_1726_64.t2 27.3158
R559 a_1726_64.n0 a_1726_64.t0 5.45406
R560 a_278_64.t1 a_278_64.n0 10.9962
R561 a_278_64.n0 a_278_64.t2 27.8832
R562 a_278_64.n0 a_278_64.t0 5.4345
R563 a_808_64.t1 a_808_64.n0 10.9883
R564 a_808_64.n0 a_808_64.n2 0.912239
R565 a_808_64.n2 a_808_64.n1 0.21963
R566 a_808_64.n1 a_808_64.t3 27.5584
R567 a_808_64.n2 a_808_64.t2 10.9883
R568 a_808_64.n1 a_808_64.t4 34.7743
R569 a_808_64.n0 a_808_64.t0 5.44232
R570 a_808_250.t0 a_808_250.t1 3.2505
R571 a_278_250.t0 a_278_250.t1 3.2505
R572 a_142_344.t1 a_142_344.n0 11.3343
R573 a_142_344.n0 a_142_344.n3 23.9216
R574 a_142_344.n3 a_142_344.n2 22.867
R575 a_142_344.n2 a_142_344.t2 27.2141
R576 a_142_344.n2 a_142_344.t4 34.5141
R577 a_142_344.n3 a_142_344.n1 23.4701
R578 a_142_344.n1 a_142_344.t3 27.6934
R579 a_142_344.n1 a_142_344.t5 34.8761
R580 a_142_344.n0 a_142_344.t0 5.2255
R581 a_672_184.t1 a_672_184.n0 11.3343
R582 a_672_184.n0 a_672_184.n2 18.1011
R583 a_672_184.n2 a_672_184.n6 21.0957
R584 a_672_184.n6 a_672_184.t4 27.1945
R585 a_672_184.n6 a_672_184.n3 0.458326
R586 a_672_184.n3 a_672_184.n4 10.3216
R587 a_672_184.n4 a_672_184.n5 1.47264
R588 a_672_184.n5 a_672_184.t2 38.668
R589 a_672_184.n5 a_672_184.t3 36.2833
R590 a_672_184.n4 a_672_184.t8 43.0719
R591 a_672_184.n3 a_672_184.t6 34.0719
R592 a_672_184.n2 a_672_184.n1 19.3903
R593 a_672_184.n1 a_672_184.t7 44.6341
R594 a_672_184.n1 a_672_184.t5 35.7719
R595 a_672_184.n0 a_672_184.t0 5.2255
C0 V 3v3 1.85426f
C1 DN 3v3 1.11207f
C2 DN UP 0.15938f
C3 V DN 0.01551f
C4 UPB 3v3 0.6337f
C5 UPB UP 0.18203f
C6 V UPB 0.38456f
C7 3v3 R 2.812f
C8 UP R 0.87412f
C9 V R 0.19527f
C10 DN UPB 1.85245f
C11 UP 3v3 2.20932f
C12 V vss 4.29682f
C13 UPB vss 4.9875f
C14 DN vss 4.25077f
C15 UP vss 2.85747f
C16 R vss 3.43511f
C17 3v3 vss 60.25103f
C18 a_672_184.t1 vss 0.03339f
C19 a_672_184.t0 vss 0.06086f
C20 a_672_184.n0 vss 0.13594f
C21 a_672_184.n1 vss 0.92934f
C22 a_672_184.t5 vss 0.03139f
C23 a_672_184.t7 vss 0.05123f
C24 a_672_184.n2 vss 3.47603f
C25 a_672_184.t6 vss 0.03447f
C26 a_672_184.n3 vss 0.08064f
C27 a_672_184.t8 vss 0.04575f
C28 a_672_184.n4 vss 0.3098f
C29 a_672_184.t3 vss 0.03869f
C30 a_672_184.n5 vss 0.56572f
C31 a_672_184.t2 vss 0.04822f
C32 a_672_184.t4 vss 0.02026f
C33 a_672_184.n6 vss 0.25675f
C34 a_142_344.t1 vss 0.02054f
C35 a_142_344.t0 vss 0.03743f
C36 a_142_344.n0 vss 0.1562f
C37 a_142_344.t5 vss 0.02221f
C38 a_142_344.t3 vss 0.0134f
C39 a_142_344.n1 vss 0.18866f
C40 a_142_344.t4 vss 0.02163f
C41 a_142_344.t2 vss 0.01249f
C42 a_142_344.n2 vss 0.13828f
C43 a_142_344.n3 vss 2.86387f
C44 a_278_250.t0 vss 0.01881f
C45 a_278_250.t1 vss 0.01881f
C46 a_808_250.t0 vss 0.01486f
C47 a_808_250.t1 vss 0.01486f
C48 a_808_64.t1 vss 0.05363f
C49 a_808_64.t0 vss 0.10827f
C50 a_808_64.n0 vss 0.27642f
C51 a_808_64.t4 vss 0.06056f
C52 a_808_64.n1 vss 0.32592f
C53 a_808_64.t2 vss 0.05363f
C54 a_808_64.n2 vss 0.1396f
C55 a_808_64.t3 vss 0.03601f
C56 a_278_64.t1 vss 0.05234f
C57 a_278_64.t0 vss 0.10536f
C58 a_278_64.n0 vss 0.40292f
C59 a_278_64.t2 vss 0.0371f
C60 a_1726_64.t1 vss 0.05071f
C61 a_1726_64.t0 vss 0.10281f
C62 a_1726_64.n0 vss 0.24818f
C63 a_1726_64.t2 vss 0.03289f
C64 a_1726_64.t3 vss 0.05592f
C65 a_1726_64.n1 vss 0.25896f
C66 a_3326_100.t0 vss 0.05352f
C67 a_3326_100.t1 vss 0.10772f
C68 a_3326_100.n0 vss 0.26223f
C69 a_3326_100.t2 vss 0.03806f
C70 a_3326_100.t3 vss 0.05953f
C71 a_3326_100.n1 vss 0.37896f
C72 a_6196_n3250.t1 vss 0.0286f
C73 a_6196_n3250.t0 vss 0.05213f
C74 a_6196_n3250.n0 vss 0.16329f
C75 a_6196_n3250.n1 vss 0.3211f
C76 a_6196_n3250.t4 vss 0.02128f
C77 a_6196_n3250.t2 vss 0.03891f
C78 a_6196_n3250.n2 vss 0.94996f
C79 a_6196_n3250.n3 vss 0.30491f
C80 a_6196_n3250.t6 vss 0.02128f
C81 a_6196_n3250.t8 vss 0.03891f
C82 a_6196_n3250.n4 vss 0.31297f
C83 a_6196_n3250.t7 vss 0.02128f
C84 a_6196_n3250.t9 vss 0.04f
C85 a_6196_n3250.n5 vss 0.3582f
C86 a_6196_n3250.t5 vss 0.02128f
C87 a_6196_n3250.t3 vss 0.04f
C88 a_6196_n3250.n6 vss 1.58866f
C89 a_6196_n3250.n7 vss 2.28378f
C90 a_2278_n16.t1 vss 0.03498f
C91 a_2278_n16.t0 vss 0.06375f
C92 a_2278_n16.n0 vss 0.51365f
C93 a_2278_n16.n1 vss 0.80876f
C94 a_2278_n16.t2 vss 0.02603f
C95 a_2278_n16.t3 vss 0.04808f
C96 a_3846_158.t1 vss 0.04831f
C97 a_3846_158.t3 vss 0.03131f
C98 a_3846_158.t4 vss 0.0529f
C99 a_3846_158.n0 vss 0.2487f
C100 a_3846_158.t2 vss 0.09641f
C101 a_3846_158.n1 vss 0.19489f
C102 a_3846_158.t0 vss 0.10853f
C103 a_3846_158.n2 vss 0.26123f
C104 a_6332_280.t0 vss 0.01737f
C105 a_6332_280.t1 vss 0.01737f
C106 a_6244_n236.t0 vss 0.05f
C107 a_6244_n236.t2 vss 0.04985f
C108 a_6244_n236.t1 vss 0.09865f
C109 a_6244_n236.n0 vss 0.19811f
C110 a_6244_n236.t3 vss 0.0312f
C111 a_6244_n236.t4 vss 0.05523f
C112 a_6244_n236.n1 vss 0.26334f
C113 a_6244_n236.n2 vss 0.15514f
C114 a_8686_442.t0 vss 0.01916f
C115 a_8686_442.t1 vss 0.01916f
C116 a_9220_440.t0 vss 0.01958f
C117 a_9220_440.t1 vss 0.01958f
C118 a_8144_84.t1 vss 0.05843f
C119 a_8144_84.n0 vss 1.11135f
C120 a_8144_84.t2 vss 0.34201f
C121 a_8144_84.t0 vss 0.11912f
C122 a_9220_254.t1 vss 0.05179f
C123 a_9220_254.t0 vss 0.10513f
C124 a_9220_254.n0 vss 0.2577f
C125 a_9220_254.n1 vss 0.29597f
C126 a_9220_254.t4 vss 0.04512f
C127 a_9220_254.t5 vss 0.06668f
C128 a_9220_254.n2 vss 0.59664f
C129 a_9220_254.t2 vss 0.10552f
C130 a_9220_254.t3 vss 0.05208f
C131 a_8686_282.t0 vss 0.02256f
C132 a_8686_282.t1 vss 0.02256f
C133 a_10128_n86.t0 vss 0.05135f
C134 a_10128_n86.t3 vss 0.0315f
C135 a_10128_n86.t4 vss 0.05478f
C136 a_10128_n86.n0 vss 0.24702f
C137 a_10128_n86.t1 vss 0.10167f
C138 a_10128_n86.n1 vss 0.25542f
C139 a_10128_n86.t2 vss 0.05032f
C140 a_10128_n86.n2 vss 0.13195f
C141 a_8566_n246.t1 vss 0.05214f
C142 a_8566_n246.t2 vss 0.05206f
C143 a_8566_n246.t0 vss 0.10219f
C144 a_8566_n246.n0 vss 0.33985f
C145 a_8566_n246.t3 vss 0.03665f
C146 a_8566_n246.n1 vss 0.16384f
C147 a_12036_n1242.t2 vss 0.04816f
C148 a_12036_n1242.t3 vss 0.03122f
C149 a_12036_n1242.t4 vss 0.05274f
C150 a_12036_n1242.n0 vss 0.24794f
C151 a_12036_n1242.t1 vss 0.09612f
C152 a_12036_n1242.n1 vss 0.19429f
C153 a_12036_n1242.t0 vss 0.1082f
C154 a_12036_n1242.n2 vss 0.26044f
C155 a_14186_n1300.t1 vss 0.05239f
C156 a_14186_n1300.t0 vss 0.10546f
C157 a_14186_n1300.n0 vss 0.25671f
C158 a_14186_n1300.t2 vss 0.03726f
C159 a_14186_n1300.t3 vss 0.05828f
C160 a_14186_n1300.n1 vss 0.37099f
C161 a_14706_n1242.t1 vss 0.04726f
C162 a_14706_n1242.t3 vss 0.03064f
C163 a_14706_n1242.t4 vss 0.05176f
C164 a_14706_n1242.n0 vss 0.24333f
C165 a_14706_n1242.t0 vss 0.09433f
C166 a_14706_n1242.n1 vss 0.19068f
C167 a_14706_n1242.t2 vss 0.10618f
C168 a_14706_n1242.n2 vss 0.25559f
C169 a_142_n3220.t1 vss 0.02225f
C170 a_142_n3220.t0 vss 0.04056f
C171 a_142_n3220.n0 vss 0.25399f
C172 a_142_n3220.t4 vss 0.01353f
C173 a_142_n3220.t3 vss 0.02344f
C174 a_142_n3220.n1 vss 0.17911f
C175 a_142_n3220.n2 vss 2.97078f
C176 a_142_n3220.t5 vss 0.01452f
C177 a_142_n3220.t2 vss 0.02406f
C178 a_142_n3220.n3 vss 0.30822f
C179 a_278_n2994.t1 vss 0.05216f
C180 a_278_n2994.t0 vss 0.105f
C181 a_278_n2994.n0 vss 0.40156f
C182 a_278_n2994.t2 vss 0.03698f
C183 a_672_n3060.t1 vss 0.03793f
C184 a_672_n3060.t0 vss 0.06912f
C185 a_672_n3060.n0 vss 0.17411f
C186 a_672_n3060.t7 vss 0.02301f
C187 a_672_n3060.t3 vss 0.03915f
C188 a_672_n3060.n1 vss 0.09158f
C189 a_672_n3060.t2 vss 0.05196f
C190 a_672_n3060.n2 vss 0.35184f
C191 a_672_n3060.t6 vss 0.04394f
C192 a_672_n3060.n3 vss 0.64251f
C193 a_672_n3060.t5 vss 0.05476f
C194 a_672_n3060.n4 vss 0.18923f
C195 a_672_n3060.n5 vss 0.46901f
C196 a_672_n3060.t8 vss 0.03565f
C197 a_672_n3060.t4 vss 0.05819f
C198 a_672_n3060.n6 vss 4.32258f
C199 a_808_n2994.t1 vss 0.0535f
C200 a_808_n2994.t4 vss 0.03592f
C201 a_808_n2994.t0 vss 0.10801f
C202 a_808_n2994.t2 vss 0.0535f
C203 a_808_n2994.n0 vss 0.27574f
C204 a_808_n2994.t3 vss 0.06041f
C205 a_808_n2994.n1 vss 0.32513f
C206 a_808_n2994.n2 vss 0.13927f
C207 a_1726_n2994.t0 vss 0.05094f
C208 a_1726_n2994.t1 vss 0.10327f
C209 a_1726_n2994.n0 vss 0.2493f
C210 a_1726_n2994.t2 vss 0.05617f
C211 a_1726_n2994.t3 vss 0.03304f
C212 a_1726_n2994.n1 vss 0.26013f
C213 a_2278_n2914.t0 vss 0.03653f
C214 a_2278_n2914.t1 vss 0.06657f
C215 a_2278_n2914.n0 vss 0.63672f
C216 a_2278_n2914.n1 vss 0.97379f
C217 a_2278_n2914.t3 vss 0.02718f
C218 a_2278_n2914.t2 vss 0.05021f
C219 a_3326_n3030.t0 vss 0.05361f
C220 a_3326_n3030.t1 vss 0.10792f
C221 a_3326_n3030.n0 vss 0.2627f
C222 a_3326_n3030.t2 vss 0.05964f
C223 a_3326_n3030.t3 vss 0.03813f
C224 a_3326_n3030.n1 vss 0.37965f
C225 a_3846_n3088.t2 vss 0.04791f
C226 a_3846_n3088.t3 vss 0.05247f
C227 a_3846_n3088.t4 vss 0.03106f
C228 a_3846_n3088.n0 vss 0.24666f
C229 a_3846_n3088.t0 vss 0.10764f
C230 a_3846_n3088.t1 vss 0.09562f
C231 a_3846_n3088.n1 vss 0.19329f
C232 a_3846_n3088.n2 vss 0.25909f
C233 a_6244_n2686.t1 vss 0.05017f
C234 a_6244_n2686.t2 vss 0.05002f
C235 a_6244_n2686.t0 vss 0.09899f
C236 a_6244_n2686.n0 vss 0.19879f
C237 a_6244_n2686.t3 vss 0.05542f
C238 a_6244_n2686.t4 vss 0.03131f
C239 a_6244_n2686.n1 vss 0.26424f
C240 a_6244_n2686.n2 vss 0.15567f
C241 a_8144_n3014.t1 vss 0.0539f
C242 a_8144_n3014.n0 vss 1.02521f
C243 a_8144_n3014.t2 vss 0.3155f
C244 a_8144_n3014.t0 vss 0.10989f
C245 a_8566_n2676.t0 vss 0.05208f
C246 a_8566_n2676.t1 vss 0.052f
C247 a_8566_n2676.t2 vss 0.10207f
C248 a_8566_n2676.n0 vss 0.33946f
C249 a_8566_n2676.t3 vss 0.03661f
C250 a_8566_n2676.n1 vss 0.16365f
C251 a_9220_n3184.t2 vss 0.05155f
C252 a_9220_n3184.t0 vss 0.10465f
C253 a_9220_n3184.n0 vss 0.25653f
C254 a_9220_n3184.n1 vss 0.29462f
C255 a_9220_n3184.t4 vss 0.06638f
C256 a_9220_n3184.t5 vss 0.04492f
C257 a_9220_n3184.n2 vss 0.59391f
C258 a_9220_n3184.t3 vss 0.05185f
C259 a_9220_n3184.t1 vss 0.10503f
C260 a_9328_n2658.t0 vss 0.01f
C261 a_9328_n2658.t1 vss 0.01f
C262 a_10128_n2836.t0 vss 0.05025f
C263 a_10128_n2836.t3 vss 0.0547f
C264 a_10128_n2836.t4 vss 0.03146f
C265 a_10128_n2836.n0 vss 0.24666f
C266 a_10128_n2836.t1 vss 0.05128f
C267 a_10128_n2836.t2 vss 0.10153f
C268 a_10128_n2836.n1 vss 0.25505f
C269 a_10128_n2836.n2 vss 0.13176f
C270 a_278_n3154.t0 vss 0.01939f
C271 a_278_n3154.t1 vss 0.01939f
C272 a_808_n3154.t0 vss 0.01496f
C273 a_808_n3154.t1 vss 0.01496f
C274 a_6332_n3184.t0 vss 0.01626f
C275 a_6332_n3184.t1 vss 0.01626f
C276 a_8686_n3186.t0 vss 0.02218f
C277 a_8686_n3186.t1 vss 0.02218f
C278 a_8686_n3346.t0 vss 0.01906f
C279 a_8686_n3346.t1 vss 0.01906f
C280 a_9220_n3344.t0 vss 0.01933f
C281 a_9220_n3344.t1 vss 0.01933f
C282 3v3.t78 vss 0.41785f
C283 3v3.t80 vss 0.40166f
C284 3v3.t36 vss 0.22648f
C285 3v3.t54 vss 0.08292f
C286 3v3.t25 vss 0.15378f
C287 3v3.t28 vss 0.39193f
C288 3v3.t27 vss 0.17818f
C289 3v3.t55 vss 0.044f
C290 3v3.n0 vss 0.07932f
C291 3v3.t65 vss 0.16001f
C292 3v3.n1 vss 0.25918f
C293 3v3.n2 vss 0.20538f
C294 3v3.n3 vss 0.05388f
C295 3v3.t79 vss 0.02491f
C296 3v3.t81 vss 0.01967f
C297 3v3.n4 vss 0.06699f
C298 3v3.t66 vss 0.01967f
C299 3v3.n5 vss 0.04408f
C300 3v3.t56 vss 0.01967f
C301 3v3.n6 vss 0.05647f
C302 3v3.t37 vss 0.0286f
C303 3v3.t29 vss 0.01967f
C304 3v3.n7 vss 0.09479f
C305 3v3.n8 vss 0.05136f
C306 3v3.t19 vss 0.01405f
C307 3v3.n9 vss 0.08345f
C308 3v3.t48 vss 0.4375f
C309 3v3.t16 vss 0.40166f
C310 3v3.t50 vss 0.39193f
C311 3v3.t63 vss 0.22648f
C312 3v3.t7 vss 0.08292f
C313 3v3.t20 vss 0.15378f
C314 3v3.t18 vss 0.17818f
C315 3v3.t5 vss 0.044f
C316 3v3.n10 vss 0.07932f
C317 3v3.t61 vss 0.16001f
C318 3v3.n11 vss 0.25918f
C319 3v3.n12 vss 0.20538f
C320 3v3.n13 vss 0.05388f
C321 3v3.t49 vss 0.02491f
C322 3v3.t17 vss 0.01967f
C323 3v3.n14 vss 0.06699f
C324 3v3.t62 vss 0.01967f
C325 3v3.n15 vss 0.04408f
C326 3v3.t6 vss 0.01967f
C327 3v3.n16 vss 0.05647f
C328 3v3.t64 vss 0.0286f
C329 3v3.t51 vss 0.01967f
C330 3v3.n17 vss 0.09479f
C331 3v3.n18 vss 0.04948f
C332 3v3.t14 vss 0.03194f
C333 3v3.t26 vss 0.0216f
C334 3v3.n19 vss 0.21434f
C335 3v3.t43 vss 0.02639f
C336 3v3.t3 vss 0.02051f
C337 3v3.n20 vss 0.15769f
C338 3v3.t13 vss 0.47327f
C339 3v3.t4 vss 0.29477f
C340 3v3.t2 vss 0.62101f
C341 3v3.n21 vss 0.48238f
C342 3v3.n22 vss 0.02341f
C343 3v3.t74 vss 0.02705f
C344 3v3.t33 vss 0.0288f
C345 3v3.t45 vss 0.02043f
C346 3v3.n23 vss 0.1586f
C347 3v3.t32 vss 0.30259f
C348 3v3.t44 vss 0.2648f
C349 3v3.t73 vss 0.28699f
C350 3v3.t30 vss 0.2648f
C351 3v3.n24 vss 0.08728f
C352 3v3.n25 vss -0.05828f
C353 3v3.t31 vss 0.02043f
C354 3v3.n26 vss 0.17968f
C355 3v3.t47 vss 0.03194f
C356 3v3.t83 vss 0.0216f
C357 3v3.n27 vss 0.21434f
C358 3v3.t75 vss 0.02639f
C359 3v3.t53 vss 0.02051f
C360 3v3.n28 vss 0.15769f
C361 3v3.t46 vss 0.37357f
C362 3v3.t82 vss 0.42681f
C363 3v3.t52 vss 0.39693f
C364 3v3.t15 vss 0.42681f
C365 3v3.n29 vss 0.3078f
C366 3v3.n30 vss -0.06047f
C367 3v3.n31 vss 0.02337f
C368 3v3.n32 vss 1.33305f
C369 3v3.n33 vss 1.25055f
C370 3v3.t85 vss 0.02705f
C371 3v3.t42 vss 0.0288f
C372 3v3.t70 vss 0.02043f
C373 3v3.n34 vss 0.1586f
C374 3v3.t41 vss 0.3057f
C375 3v3.t84 vss 0.07654f
C376 3v3.t59 vss 0.39248f
C377 3v3.n35 vss 0.37348f
C378 3v3.t60 vss 0.02043f
C379 3v3.n36 vss 0.16354f
C380 3v3.n37 vss 0.49383f
C381 3v3.t1 vss 0.02569f
C382 3v3.t8 vss 0.19922f
C383 3v3.t0 vss 0.08712f
C384 3v3.t71 vss 0.23074f
C385 3v3.n38 vss 0.29836f
C386 3v3.t72 vss 0.02045f
C387 3v3.n39 vss 0.08711f
C388 3v3.n40 vss 0.54264f
C389 3v3.n41 vss 0.32856f
C390 3v3.t21 vss 0.01484f
C391 3v3.n42 vss 0.10282f
C392 3v3.t12 vss 0.02705f
C393 3v3.t35 vss 0.0288f
C394 3v3.t23 vss 0.02043f
C395 3v3.n43 vss 0.1586f
C396 3v3.t34 vss 0.3057f
C397 3v3.t11 vss 0.07654f
C398 3v3.t22 vss 0.39248f
C399 3v3.n44 vss 0.37348f
C400 3v3.t69 vss 0.02043f
C401 3v3.n45 vss 0.16354f
C402 3v3.n46 vss 0.18723f
C403 3v3.t77 vss 0.0288f
C404 3v3.t76 vss 0.31209f
C405 3v3.t9 vss 0.29047f
C406 3v3.t38 vss 0.17699f
C407 3v3.n47 vss 0.14967f
C408 3v3.t39 vss 0.02043f
C409 3v3.n48 vss 0.11576f
C410 3v3.t10 vss 0.02043f
C411 3v3.n49 vss 0.09347f
C412 3v3.n50 vss 1.79716f
C413 3v3.n51 vss 0.15997f
C414 3v3.n52 vss 0.40052f
C415 3v3.t24 vss 0.01405f
C416 3v3.n53 vss 0.08693f
C417 3v3.n54 vss 0.74089f
C418 3v3.t68 vss 0.02569f
C419 3v3.t40 vss 0.19922f
C420 3v3.t67 vss 0.08712f
C421 3v3.t57 vss 0.23074f
C422 3v3.n55 vss 0.29836f
C423 3v3.t58 vss 0.02045f
C424 3v3.n56 vss 0.09069f
C425 3v3.n57 vss 0.41789f
C426 3v3.n58 vss 0.42052f
C427 R.t1 vss 0.02432f
C428 R.t5 vss 0.0403f
C429 R.t4 vss 0.04051f
C430 R.n0 vss 0.34482f
C431 R.t0 vss 0.02428f
C432 R.n1 vss 0.19061f
C433 R.n2 vss 0.45168f
C434 R.t2 vss 0.02984f
C435 R.t3 vss 0.02432f
C436 R.t7 vss 0.03917f
C437 R.t6 vss 0.04066f
C438 R.n3 vss 0.30505f
C439 R.n4 vss 0.37587f
C440 R.n5 vss 6.87179f
C441 UP.t1 vss 0.04843f
C442 UP.t0 vss 0.02657f
C443 UP.n0 vss 0.10775f
C444 UP.t4 vss 0.02799f
C445 UP.t3 vss 0.01615f
C446 UP.n1 vss 0.17308f
C447 UP.t5 vss 0.0283f
C448 UP.t2 vss 0.01787f
C449 UP.n2 vss 0.24226f
C450 UP.n3 vss 1.7261f
C451 UP.t7 vss 0.02844f
C452 UP.t6 vss 0.01576f
C453 UP.n4 vss 0.32974f
C454 UP.n5 vss 2.71825f
C455 DN.t5 vss 0.02403f
C456 DN.t4 vss 0.01301f
C457 DN.n0 vss 0.21674f
C458 DN.t1 vss 0.03186f
C459 DN.t0 vss 0.01748f
C460 DN.n1 vss 0.08004f
C461 DN.n2 vss 1.48702f
C462 DN.t3 vss 0.01037f
C463 DN.t2 vss 0.01871f
C464 DN.n3 vss 0.19869f
C465 DN.n4 vss 1.56444f
C466 UPB.t1 vss 0.03334f
C467 UPB.t0 vss 0.0183f
C468 UPB.n0 vss 0.97763f
C469 V.t4 vss 0.0238f
C470 V.t0 vss 0.03944f
C471 V.t1 vss 0.03965f
C472 V.n0 vss 0.33748f
C473 V.t5 vss 0.02376f
C474 V.n1 vss 0.18655f
C475 V.n2 vss 0.37277f
C476 V.t6 vss 0.02921f
C477 V.t7 vss 0.0238f
C478 V.t2 vss 0.03834f
C479 V.t3 vss 0.0398f
C480 V.n3 vss 0.29857f
C481 V.n4 vss 0.48419f
C482 V.n5 vss 5.10357f
.ends
